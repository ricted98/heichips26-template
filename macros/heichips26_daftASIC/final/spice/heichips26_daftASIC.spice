* NGSPICE file created from heichips26_daftASIC.ext - technology: ihp-sg13cmos5l

* Black-box entry subcircuit for sg13cmos5l_decap_8 abstract view
.subckt sg13cmos5l_decap_8 VDD VSS
.ends

* Black-box entry subcircuit for sg13cmos5l_buf_1 abstract view
.subckt sg13cmos5l_buf_1 X A VDD VSS
.ends

* Black-box entry subcircuit for sg13cmos5l_dfrbpq_1 abstract view
.subckt sg13cmos5l_dfrbpq_1 Q CLK D RESET_B VDD VSS
.ends

* Black-box entry subcircuit for sg13cmos5l_o21ai_1 abstract view
.subckt sg13cmos5l_o21ai_1 Y A1 A2 B1 VDD VSS
.ends

* Black-box entry subcircuit for sg13cmos5l_nand2_1 abstract view
.subckt sg13cmos5l_nand2_1 Y A B VDD VSS
.ends

* Black-box entry subcircuit for sg13cmos5l_decap_4 abstract view
.subckt sg13cmos5l_decap_4 VDD VSS
.ends

* Black-box entry subcircuit for sg13cmos5l_nand3_1 abstract view
.subckt sg13cmos5l_nand3_1 Y A B C VDD VSS
.ends

* Black-box entry subcircuit for sg13cmos5l_dlygate4sd3_1 abstract view
.subckt sg13cmos5l_dlygate4sd3_1 X A VDD VSS
.ends

* Black-box entry subcircuit for sg13cmos5l_fill_1 abstract view
.subckt sg13cmos5l_fill_1 VDD VSS
.ends

* Black-box entry subcircuit for sg13cmos5l_fill_2 abstract view
.subckt sg13cmos5l_fill_2 VDD VSS
.ends

* Black-box entry subcircuit for sg13cmos5l_nor2b_1 abstract view
.subckt sg13cmos5l_nor2b_1 Y A B_N VDD VSS
.ends

* Black-box entry subcircuit for sg13cmos5l_nor2_1 abstract view
.subckt sg13cmos5l_nor2_1 Y A B VDD VSS
.ends

* Black-box entry subcircuit for sg13cmos5l_mux2_1 abstract view
.subckt sg13cmos5l_mux2_1 X A0 A1 S VDD VSS
.ends

* Black-box entry subcircuit for sg13cmos5l_a22oi_1 abstract view
.subckt sg13cmos5l_a22oi_1 Y A1 A2 B1 B2 VDD VSS
.ends

* Black-box entry subcircuit for sg13cmos5l_nand4_1 abstract view
.subckt sg13cmos5l_nand4_1 Y A B C D VDD VSS
.ends

* Black-box entry subcircuit for sg13cmos5l_buf_8 abstract view
.subckt sg13cmos5l_buf_8 X A VDD VSS
.ends

* Black-box entry subcircuit for sg13cmos5l_a221oi_1 abstract view
.subckt sg13cmos5l_a221oi_1 Y A1 A2 B1 B2 C1 VDD VSS
.ends

* Black-box entry subcircuit for sg13cmos5l_nor3_1 abstract view
.subckt sg13cmos5l_nor3_1 Y A B C VDD VSS
.ends

* Black-box entry subcircuit for sg13cmos5l_a21oi_1 abstract view
.subckt sg13cmos5l_a21oi_1 Y A1 A2 B1 VDD VSS
.ends

* Black-box entry subcircuit for sg13cmos5l_or2_1 abstract view
.subckt sg13cmos5l_or2_1 X A B VDD VSS
.ends

* Black-box entry subcircuit for sg13cmos5l_inv_1 abstract view
.subckt sg13cmos5l_inv_1 Y A VDD VSS
.ends

* Black-box entry subcircuit for sg13cmos5l_a21o_1 abstract view
.subckt sg13cmos5l_a21o_1 X A1 A2 B1 VDD VSS
.ends

* Black-box entry subcircuit for sg13cmos5l_nand3b_1 abstract view
.subckt sg13cmos5l_nand3b_1 Y A_N B C VDD VSS
.ends

* Black-box entry subcircuit for sg13cmos5l_nor4_1 abstract view
.subckt sg13cmos5l_nor4_1 Y A B C D VDD VSS
.ends

* Black-box entry subcircuit for sg13cmos5l_and2_1 abstract view
.subckt sg13cmos5l_and2_1 X A B VDD VSS
.ends

* Black-box entry subcircuit for sg13cmos5l_xnor2_1 abstract view
.subckt sg13cmos5l_xnor2_1 Y A B VDD VSS
.ends

* Black-box entry subcircuit for sg13cmos5l_nand2b_1 abstract view
.subckt sg13cmos5l_nand2b_1 Y A_N B VDD VSS
.ends

* Black-box entry subcircuit for sg13cmos5l_and3_1 abstract view
.subckt sg13cmos5l_and3_1 X A B C VDD VSS
.ends

* Black-box entry subcircuit for sg13cmos5l_mux4_1 abstract view
.subckt sg13cmos5l_mux4_1 X A0 A1 A2 A3 S0 S1 VDD VSS
.ends

* Black-box entry subcircuit for sg13cmos5l_xor2_1 abstract view
.subckt sg13cmos5l_xor2_1 X A B VDD VSS
.ends

* Black-box entry subcircuit for sg13cmos5l_or3_1 abstract view
.subckt sg13cmos5l_or3_1 X A B C VDD VSS
.ends

* Black-box entry subcircuit for sg13cmos5l_or4_1 abstract view
.subckt sg13cmos5l_or4_1 X A B C D VDD VSS
.ends

* Black-box entry subcircuit for sg13cmos5l_tielo abstract view
.subckt sg13cmos5l_tielo L_LO VDD VSS
.ends

* Black-box entry subcircuit for sg13cmos5l_tiehi abstract view
.subckt sg13cmos5l_tiehi L_HI VDD VSS
.ends

* Black-box entry subcircuit for sg13cmos5l_and4_1 abstract view
.subckt sg13cmos5l_and4_1 X A B C D VDD VSS
.ends

.subckt heichips26_daftASIC VGND VPWR clk ena rst_n ui_in[0] ui_in[1] ui_in[2] ui_in[3]
+ ui_in[4] ui_in[5] ui_in[6] ui_in[7] uio_in[0] uio_in[1] uio_in[2] uio_in[3] uio_in[4]
+ uio_in[5] uio_in[6] uio_in[7] uio_oe[0] uio_oe[1] uio_oe[2] uio_oe[3] uio_oe[4]
+ uio_oe[5] uio_oe[6] uio_oe[7] uio_out[0] uio_out[1] uio_out[2] uio_out[3] uio_out[4]
+ uio_out[5] uio_out[6] uio_out[7] uo_out[0] uo_out[1] uo_out[2] uo_out[3] uo_out[4]
+ uo_out[5] uo_out[6] uo_out[7]
XFILLER_39_211 VPWR VGND sg13cmos5l_decap_8
X_3155_ _3155_/X _3155_/A VPWR VGND sg13cmos5l_buf_1
X_3086_ _3086_/Q _3103_/CLK _3086_/D fanout163/X VPWR VGND sg13cmos5l_dfrbpq_1
X_2106_ _2106_/Y _2032_/A _2294_/B _2158_/B VPWR VGND sg13cmos5l_o21ai_1
XFILLER_27_439 VPWR VGND sg13cmos5l_decap_8
X_2037_ _2231_/B _2037_/A _2194_/A VPWR VGND sg13cmos5l_nand2_1
XFILLER_35_494 VPWR VGND sg13cmos5l_decap_8
XFILLER_22_166 VPWR VGND sg13cmos5l_decap_8
XFILLER_23_689 VPWR VGND sg13cmos5l_decap_4
X_2939_ _2940_/D _2939_/A _2939_/B _2939_/C VPWR VGND sg13cmos5l_nand3_1
XFILLER_10_339 VPWR VGND sg13cmos5l_decap_8
XFILLER_11_1020 VPWR VGND sg13cmos5l_decap_8
Xhold362 _2554_/A _2553_/Y VPWR VGND sg13cmos5l_dlygate4sd3_1
Xhold340 _2778_/A _3045_/Q VPWR VGND sg13cmos5l_dlygate4sd3_1
XFILLER_7_7 VPWR VGND sg13cmos5l_fill_1
XFILLER_2_516 VPWR VGND sg13cmos5l_decap_4
Xhold351 _2889_/A _3072_/Q VPWR VGND sg13cmos5l_dlygate4sd3_1
Xhold384 _2464_/B _3029_/Q VPWR VGND sg13cmos5l_dlygate4sd3_1
Xhold395 _1824_/B _1823_/Y VPWR VGND sg13cmos5l_dlygate4sd3_1
Xhold373 hold373/X _2627_/Y VPWR VGND sg13cmos5l_dlygate4sd3_1
XFILLER_18_417 VPWR VGND sg13cmos5l_decap_8
XFILLER_46_759 VPWR VGND sg13cmos5l_decap_8
XFILLER_45_203 VPWR VGND sg13cmos5l_decap_4
XFILLER_45_247 VPWR VGND sg13cmos5l_fill_2
XFILLER_27_962 VPWR VGND sg13cmos5l_decap_8
XFILLER_42_910 VPWR VGND sg13cmos5l_decap_8
XFILLER_14_612 VPWR VGND sg13cmos5l_fill_2
XFILLER_13_111 VPWR VGND sg13cmos5l_decap_8
XFILLER_13_122 VPWR VGND sg13cmos5l_fill_2
XFILLER_14_645 VPWR VGND sg13cmos5l_decap_8
XFILLER_42_987 VPWR VGND sg13cmos5l_decap_8
XFILLER_42_62 VPWR VGND sg13cmos5l_fill_1
XFILLER_9_137 VPWR VGND sg13cmos5l_decap_8
XFILLER_13_177 VPWR VGND sg13cmos5l_fill_1
XFILLER_6_844 VPWR VGND sg13cmos5l_decap_8
XFILLER_5_310 VPWR VGND sg13cmos5l_decap_8
XFILLER_10_895 VPWR VGND sg13cmos5l_decap_8
XFILLER_49_597 VPWR VGND sg13cmos5l_decap_8
XFILLER_24_409 VPWR VGND sg13cmos5l_decap_8
XFILLER_45_792 VPWR VGND sg13cmos5l_decap_8
XFILLER_33_921 VPWR VGND sg13cmos5l_decap_8
XFILLER_32_464 VPWR VGND sg13cmos5l_fill_2
XFILLER_32_475 VPWR VGND sg13cmos5l_decap_8
XFILLER_33_998 VPWR VGND sg13cmos5l_decap_8
XFILLER_20_637 VPWR VGND sg13cmos5l_decap_8
X_2724_ _2732_/A _2724_/A _2754_/B VPWR VGND sg13cmos5l_nand2_1
X_2655_ _2656_/B _2655_/A _2654_/X VPWR VGND sg13cmos5l_nor2b_1
X_1606_ _1817_/A _1816_/A _1718_/B VPWR VGND sg13cmos5l_nor2_1
X_2586_ _3006_/D hold385/X _2577_/A _2589_/S VPWR VGND sg13cmos5l_mux2_1
Xfanout127 _2919_/A _3084_/Q VPWR VGND sg13cmos5l_buf_1
Xfanout138 _2022_/A _2183_/A VPWR VGND sg13cmos5l_buf_1
Xfanout116 _2297_/A _2242_/A VPWR VGND sg13cmos5l_buf_1
X_1537_ _1537_/Y _3130_/Q _2336_/A _3136_/Q _2112_/A VPWR VGND sg13cmos5l_a22oi_1
Xfanout105 _1527_/A _3121_/Q VPWR VGND sg13cmos5l_buf_1
Xfanout149 fanout149/X fanout150/X VPWR VGND sg13cmos5l_buf_1
XFILLER_43_729 VPWR VGND sg13cmos5l_decap_8
X_3069_ _3069_/Q _3072_/CLK _3069_/D fanout170/X VPWR VGND sg13cmos5l_dfrbpq_1
XFILLER_24_965 VPWR VGND sg13cmos5l_decap_8
XFILLER_23_475 VPWR VGND sg13cmos5l_decap_8
XFILLER_6_107 VPWR VGND sg13cmos5l_decap_8
XFILLER_10_136 VPWR VGND sg13cmos5l_decap_8
XFILLER_12_87 VPWR VGND sg13cmos5l_decap_4
XFILLER_3_847 VPWR VGND sg13cmos5l_decap_8
XFILLER_19_704 VPWR VGND sg13cmos5l_decap_8
XFILLER_46_534 VPWR VGND sg13cmos5l_decap_8
XFILLER_46_512 VPWR VGND sg13cmos5l_decap_8
XFILLER_18_247 VPWR VGND sg13cmos5l_decap_4
XFILLER_15_921 VPWR VGND sg13cmos5l_decap_8
XFILLER_18_269 VPWR VGND sg13cmos5l_decap_8
XFILLER_26_280 VPWR VGND sg13cmos5l_decap_4
XFILLER_26_291 VPWR VGND sg13cmos5l_decap_8
XFILLER_42_751 VPWR VGND sg13cmos5l_decap_8
XFILLER_41_250 VPWR VGND sg13cmos5l_decap_4
XFILLER_15_998 VPWR VGND sg13cmos5l_decap_8
XFILLER_14_486 VPWR VGND sg13cmos5l_fill_2
XFILLER_30_946 VPWR VGND sg13cmos5l_decap_8
XFILLER_41_294 VPWR VGND sg13cmos5l_decap_8
XFILLER_6_641 VPWR VGND sg13cmos5l_decap_8
X_2440_ _3155_/A _2440_/A _2440_/B _2440_/C VPWR VGND sg13cmos5l_nand3_1
XFILLER_5_195 VPWR VGND sg13cmos5l_decap_8
X_2371_ _2373_/B _2417_/A _2371_/B _2371_/C _2401_/B VPWR VGND sg13cmos5l_nand4_1
XFILLER_2_880 VPWR VGND sg13cmos5l_decap_8
XFILLER_37_545 VPWR VGND sg13cmos5l_decap_8
XFILLER_25_729 VPWR VGND sg13cmos5l_decap_8
XFILLER_21_913 VPWR VGND sg13cmos5l_decap_8
XFILLER_33_762 VPWR VGND sg13cmos5l_decap_8
XFILLER_20_423 VPWR VGND sg13cmos5l_decap_4
XFILLER_33_795 VPWR VGND sg13cmos5l_decap_8
XFILLER_32_294 VPWR VGND sg13cmos5l_decap_8
Xclkbuf_4_12_0_clk clkbuf_4_12_0_clk/X clkbuf_0_clk/X VPWR VGND sg13cmos5l_buf_8
XFILLER_20_478 VPWR VGND sg13cmos5l_decap_8
X_2707_ _2709_/C _2690_/Y _2692_/B _2699_/B _3035_/Q _2688_/Y VPWR VGND sg13cmos5l_a221oi_1
X_2638_ _2639_/B _2916_/A _2925_/A _2947_/B VPWR VGND sg13cmos5l_nor3_1
X_2569_ _2569_/Y _2558_/Y _2570_/B _2570_/A VPWR VGND sg13cmos5l_a21oi_1
XFILLER_0_817 VPWR VGND sg13cmos5l_decap_8
XFILLER_28_545 VPWR VGND sg13cmos5l_decap_8
XFILLER_43_526 VPWR VGND sg13cmos5l_decap_8
XFILLER_15_206 VPWR VGND sg13cmos5l_fill_1
XFILLER_23_283 VPWR VGND sg13cmos5l_fill_1
XFILLER_8_928 VPWR VGND sg13cmos5l_decap_8
XFILLER_12_968 VPWR VGND sg13cmos5l_decap_8
XFILLER_7_438 VPWR VGND sg13cmos5l_decap_4
XFILLER_11_478 VPWR VGND sg13cmos5l_fill_1
XFILLER_23_86 VPWR VGND sg13cmos5l_decap_4
XFILLER_23_97 VPWR VGND sg13cmos5l_decap_8
XFILLER_48_1019 VPWR VGND sg13cmos5l_decap_8
XFILLER_3_644 VPWR VGND sg13cmos5l_decap_8
XFILLER_3_633 VPWR VGND sg13cmos5l_decap_8
XFILLER_2_143 VPWR VGND sg13cmos5l_decap_8
XFILLER_2_198 VPWR VGND sg13cmos5l_decap_8
XFILLER_47_832 VPWR VGND sg13cmos5l_decap_8
XFILLER_47_821 VPWR VGND sg13cmos5l_decap_4
XFILLER_48_94 VPWR VGND sg13cmos5l_fill_1
XFILLER_19_501 VPWR VGND sg13cmos5l_decap_4
XFILLER_19_556 VPWR VGND sg13cmos5l_fill_2
XFILLER_0_46 VPWR VGND sg13cmos5l_decap_8
XFILLER_9_11 VPWR VGND sg13cmos5l_decap_8
XFILLER_15_762 VPWR VGND sg13cmos5l_decap_8
XFILLER_42_592 VPWR VGND sg13cmos5l_decap_8
X_1940_ _2076_/A _2186_/C _2135_/A VPWR VGND sg13cmos5l_nand2_1
XFILLER_14_261 VPWR VGND sg13cmos5l_decap_8
XFILLER_30_710 VPWR VGND sg13cmos5l_fill_2
X_1871_ _1966_/B _2186_/C _1908_/C VPWR VGND sg13cmos5l_nor2_1
XFILLER_14_294 VPWR VGND sg13cmos5l_fill_1
XFILLER_30_787 VPWR VGND sg13cmos5l_decap_8
XFILLER_7_972 VPWR VGND sg13cmos5l_decap_8
XFILLER_6_493 VPWR VGND sg13cmos5l_decap_8
X_2423_ _2641_/B _3090_/Q _2429_/B VPWR VGND sg13cmos5l_or2_1
XFILLER_9_1024 VPWR VGND sg13cmos5l_decap_4
X_2354_ _2358_/D _2392_/A _2353_/S _2353_/X VPWR VGND sg13cmos5l_o21ai_1
X_2285_ _3105_/D _2404_/C _2285_/B VPWR VGND sg13cmos5l_nor2_1
XFILLER_38_887 VPWR VGND sg13cmos5l_decap_8
XFILLER_40_507 VPWR VGND sg13cmos5l_decap_4
XFILLER_21_732 VPWR VGND sg13cmos5l_decap_8
XFILLER_21_765 VPWR VGND sg13cmos5l_decap_4
XFILLER_5_909 VPWR VGND sg13cmos5l_decap_8
XFILLER_20_297 VPWR VGND sg13cmos5l_decap_8
XFILLER_0_614 VPWR VGND sg13cmos5l_decap_8
XFILLER_29_832 VPWR VGND sg13cmos5l_decap_8
XFILLER_18_20 VPWR VGND sg13cmos5l_decap_8
XFILLER_18_31 VPWR VGND sg13cmos5l_fill_2
XFILLER_18_42 VPWR VGND sg13cmos5l_decap_8
XFILLER_16_526 VPWR VGND sg13cmos5l_decap_8
XFILLER_12_721 VPWR VGND sg13cmos5l_fill_1
XFILLER_24_570 VPWR VGND sg13cmos5l_decap_8
XFILLER_31_529 VPWR VGND sg13cmos5l_fill_1
XFILLER_34_74 VPWR VGND sg13cmos5l_fill_1
XFILLER_8_725 VPWR VGND sg13cmos5l_decap_8
XFILLER_7_213 VPWR VGND sg13cmos5l_decap_8
XFILLER_11_264 VPWR VGND sg13cmos5l_decap_8
XFILLER_4_986 VPWR VGND sg13cmos5l_decap_8
X_2070_ _2070_/Y _2076_/B VPWR VGND sg13cmos5l_inv_1
XFILLER_19_320 VPWR VGND sg13cmos5l_decap_8
XFILLER_47_651 VPWR VGND sg13cmos5l_fill_1
XFILLER_35_857 VPWR VGND sg13cmos5l_decap_8
XFILLER_19_397 VPWR VGND sg13cmos5l_fill_2
X_2972_ _2972_/Q clkload1/A _2972_/D fanout157/X VPWR VGND sg13cmos5l_dfrbpq_1
XFILLER_15_581 VPWR VGND sg13cmos5l_decap_8
XFILLER_22_529 VPWR VGND sg13cmos5l_fill_1
X_1923_ _1923_/Y _2402_/A _2322_/A VPWR VGND sg13cmos5l_nor2_1
X_1854_ _1888_/B _2246_/B _2118_/B VPWR VGND sg13cmos5l_nand2_1
X_1785_ _1786_/B _2442_/B _2927_/A VPWR VGND sg13cmos5l_nand2_1
XFILLER_6_290 VPWR VGND sg13cmos5l_decap_8
X_2406_ _2406_/Y _2404_/A _2404_/C _2404_/B VPWR VGND sg13cmos5l_a21oi_1
X_2337_ _2338_/D _2337_/A _2337_/B VPWR VGND sg13cmos5l_nand2_1
X_2268_ _2269_/C _2268_/A _2268_/B _2286_/C VPWR VGND sg13cmos5l_nor3_1
XFILLER_38_651 VPWR VGND sg13cmos5l_decap_4
X_2199_ _2225_/B _2199_/A _2199_/B _2199_/C _2199_/D VPWR VGND sg13cmos5l_nand4_1
XFILLER_25_367 VPWR VGND sg13cmos5l_fill_1
XFILLER_41_849 VPWR VGND sg13cmos5l_fill_1
XFILLER_41_838 VPWR VGND sg13cmos5l_decap_8
XFILLER_40_326 VPWR VGND sg13cmos5l_decap_8
XFILLER_40_348 VPWR VGND sg13cmos5l_decap_8
XFILLER_21_573 VPWR VGND sg13cmos5l_decap_8
XFILLER_5_706 VPWR VGND sg13cmos5l_decap_8
XFILLER_1_912 VPWR VGND sg13cmos5l_decap_8
XFILLER_0_411 VPWR VGND sg13cmos5l_decap_8
XFILLER_49_916 VPWR VGND sg13cmos5l_decap_8
XFILLER_0_488 VPWR VGND sg13cmos5l_decap_4
XFILLER_1_989 VPWR VGND sg13cmos5l_decap_8
XFILLER_48_448 VPWR VGND sg13cmos5l_decap_8
XFILLER_21_1011 VPWR VGND sg13cmos5l_decap_8
XFILLER_29_662 VPWR VGND sg13cmos5l_decap_8
XFILLER_44_632 VPWR VGND sg13cmos5l_decap_4
XFILLER_28_161 VPWR VGND sg13cmos5l_decap_8
XFILLER_29_684 VPWR VGND sg13cmos5l_decap_8
XFILLER_45_51 VPWR VGND sg13cmos5l_fill_2
XFILLER_43_131 VPWR VGND sg13cmos5l_fill_2
XFILLER_16_334 VPWR VGND sg13cmos5l_decap_8
XFILLER_16_345 VPWR VGND sg13cmos5l_fill_2
XFILLER_17_868 VPWR VGND sg13cmos5l_decap_4
XFILLER_44_698 VPWR VGND sg13cmos5l_fill_2
XFILLER_43_175 VPWR VGND sg13cmos5l_decap_8
XFILLER_12_551 VPWR VGND sg13cmos5l_decap_8
XFILLER_12_562 VPWR VGND sg13cmos5l_fill_1
XFILLER_6_34 VPWR VGND sg13cmos5l_decap_8
X_1570_ _1646_/B _1584_/A _1570_/B _1570_/C VPWR VGND sg13cmos5l_nor3_1
XFILLER_4_783 VPWR VGND sg13cmos5l_decap_8
XFILLER_6_1005 VPWR VGND sg13cmos5l_decap_8
XFILLER_20_4 VPWR VGND sg13cmos5l_decap_8
XFILLER_39_459 VPWR VGND sg13cmos5l_fill_1
XFILLER_39_448 VPWR VGND sg13cmos5l_decap_8
X_2122_ _2322_/B _2210_/A _2122_/B VPWR VGND sg13cmos5l_nor2_1
XFILLER_35_610 VPWR VGND sg13cmos5l_fill_1
X_2053_ _2055_/B _2199_/A _2404_/B VPWR VGND sg13cmos5l_nor2_1
XFILLER_35_643 VPWR VGND sg13cmos5l_decap_8
XFILLER_22_348 VPWR VGND sg13cmos5l_decap_8
XFILLER_34_186 VPWR VGND sg13cmos5l_fill_2
XFILLER_31_860 VPWR VGND sg13cmos5l_decap_8
X_2955_ _3081_/D _2746_/A _2438_/A _2967_/A VPWR VGND sg13cmos5l_o21ai_1
X_1906_ _2029_/C _1907_/A _2151_/B VPWR VGND sg13cmos5l_nor2_1
X_2886_ _2886_/Y _2886_/A1 _2885_/Y _2883_/Y VPWR VGND sg13cmos5l_o21ai_1
X_1837_ _1837_/X _1919_/B _2332_/C _1845_/A VPWR VGND sg13cmos5l_a21o_1
X_1768_ _1768_/Y _3120_/Q _3119_/Q _3118_/Q VPWR VGND sg13cmos5l_nand3b_1
X_1699_ _1699_/Y _1681_/Y _1698_/Y _1705_/C VPWR VGND sg13cmos5l_o21ai_1
XFILLER_45_407 VPWR VGND sg13cmos5l_decap_8
XFILLER_39_982 VPWR VGND sg13cmos5l_decap_8
XFILLER_41_624 VPWR VGND sg13cmos5l_fill_2
XFILLER_25_164 VPWR VGND sg13cmos5l_decap_8
XFILLER_26_687 VPWR VGND sg13cmos5l_decap_8
XFILLER_41_635 VPWR VGND sg13cmos5l_decap_8
XFILLER_40_167 VPWR VGND sg13cmos5l_decap_8
XFILLER_40_156 VPWR VGND sg13cmos5l_decap_8
XFILLER_22_882 VPWR VGND sg13cmos5l_fill_2
XFILLER_31_53 VPWR VGND sg13cmos5l_decap_8
Xoutput7 uo_out[3] _3158_/X VPWR VGND sg13cmos5l_buf_1
XFILLER_49_702 VPWR VGND sg13cmos5l_decap_8
XFILLER_1_786 VPWR VGND sg13cmos5l_decap_8
XFILLER_37_919 VPWR VGND sg13cmos5l_decap_8
XFILLER_29_470 VPWR VGND sg13cmos5l_decap_8
XFILLER_16_131 VPWR VGND sg13cmos5l_decap_8
XFILLER_45_996 VPWR VGND sg13cmos5l_decap_8
XFILLER_17_676 VPWR VGND sg13cmos5l_decap_8
XFILLER_32_602 VPWR VGND sg13cmos5l_decap_8
XFILLER_31_123 VPWR VGND sg13cmos5l_decap_4
XFILLER_13_871 VPWR VGND sg13cmos5l_decap_8
XFILLER_31_167 VPWR VGND sg13cmos5l_decap_8
X_2740_ _2740_/Y _2740_/A _2741_/A _2740_/C _2741_/C VPWR VGND sg13cmos5l_nor4_1
XFILLER_9_842 VPWR VGND sg13cmos5l_decap_8
X_2671_ _2671_/Y _3080_/Q _2933_/B _2671_/C VPWR VGND sg13cmos5l_nor3_1
Xclkbuf_5_17__f_clk clkload4/A clkbuf_4_8_0_clk/X VPWR VGND sg13cmos5l_buf_8
X_1622_ _1641_/D _1646_/B _1646_/C VPWR VGND sg13cmos5l_and2_1
X_1553_ _1560_/A _1540_/B _1571_/B _1538_/Y VPWR VGND sg13cmos5l_a21oi_1
X_1484_ _2336_/A _2612_/A VPWR VGND sg13cmos5l_inv_1
XFILLER_28_1028 VPWR VGND sg13cmos5l_fill_1
X_3085_ _3085_/Q _3085_/CLK _3085_/D fanout163/X VPWR VGND sg13cmos5l_dfrbpq_1
X_2105_ _2323_/C _2056_/B _2122_/B _1912_/Y VPWR VGND sg13cmos5l_a21oi_1
XFILLER_27_418 VPWR VGND sg13cmos5l_decap_8
XFILLER_35_440 VPWR VGND sg13cmos5l_decap_4
X_2036_ _2163_/A _2183_/C _2036_/B VPWR VGND sg13cmos5l_nor2_1
XFILLER_36_985 VPWR VGND sg13cmos5l_decap_8
XFILLER_23_613 VPWR VGND sg13cmos5l_decap_4
XFILLER_22_123 VPWR VGND sg13cmos5l_decap_8
XFILLER_23_668 VPWR VGND sg13cmos5l_decap_8
X_2938_ _2939_/C _3034_/Q _2938_/B VPWR VGND sg13cmos5l_xnor2_1
X_2869_ _2869_/Y _2869_/A _2869_/B VPWR VGND sg13cmos5l_xnor2_1
Xhold330 _2825_/B _2823_/Y VPWR VGND sg13cmos5l_dlygate4sd3_1
Xhold341 _3045_/D _2781_/Y VPWR VGND sg13cmos5l_dlygate4sd3_1
Xhold352 _3072_/D _2890_/Y VPWR VGND sg13cmos5l_dlygate4sd3_1
Xhold385 hold385/X _3006_/Q VPWR VGND sg13cmos5l_dlygate4sd3_1
Xhold396 _1821_/A _3128_/Q VPWR VGND sg13cmos5l_dlygate4sd3_1
Xhold374 _2860_/B _3065_/Q VPWR VGND sg13cmos5l_dlygate4sd3_1
Xhold363 _2429_/A _3090_/Q VPWR VGND sg13cmos5l_dlygate4sd3_1
XFILLER_46_738 VPWR VGND sg13cmos5l_decap_4
XFILLER_45_226 VPWR VGND sg13cmos5l_decap_8
XFILLER_27_941 VPWR VGND sg13cmos5l_decap_8
XFILLER_26_64 VPWR VGND sg13cmos5l_fill_2
XFILLER_26_462 VPWR VGND sg13cmos5l_decap_8
XFILLER_26_473 VPWR VGND sg13cmos5l_fill_2
XFILLER_42_966 VPWR VGND sg13cmos5l_decap_8
XFILLER_41_410 VPWR VGND sg13cmos5l_decap_8
XFILLER_14_624 VPWR VGND sg13cmos5l_decap_8
XFILLER_26_97 VPWR VGND sg13cmos5l_decap_8
XFILLER_9_116 VPWR VGND sg13cmos5l_decap_8
XFILLER_42_30 VPWR VGND sg13cmos5l_decap_8
XFILLER_10_852 VPWR VGND sg13cmos5l_decap_4
XFILLER_22_690 VPWR VGND sg13cmos5l_decap_8
XFILLER_6_823 VPWR VGND sg13cmos5l_decap_8
XFILLER_5_300 VPWR VGND sg13cmos5l_fill_1
XFILLER_10_874 VPWR VGND sg13cmos5l_decap_8
XFILLER_5_399 VPWR VGND sg13cmos5l_decap_8
XFILLER_3_13 VPWR VGND sg13cmos5l_decap_8
XFILLER_49_576 VPWR VGND sg13cmos5l_decap_8
XFILLER_37_716 VPWR VGND sg13cmos5l_decap_8
XFILLER_3_1008 VPWR VGND sg13cmos5l_decap_8
XFILLER_37_749 VPWR VGND sg13cmos5l_decap_8
XFILLER_17_462 VPWR VGND sg13cmos5l_fill_1
XFILLER_18_985 VPWR VGND sg13cmos5l_decap_8
XFILLER_33_900 VPWR VGND sg13cmos5l_decap_8
XFILLER_17_495 VPWR VGND sg13cmos5l_decap_8
XFILLER_20_605 VPWR VGND sg13cmos5l_decap_8
XFILLER_32_443 VPWR VGND sg13cmos5l_decap_8
XFILLER_33_977 VPWR VGND sg13cmos5l_decap_8
X_2723_ _3037_/D _2723_/A VPWR VGND sg13cmos5l_inv_1
XFILLER_9_661 VPWR VGND sg13cmos5l_decap_8
X_2654_ _2654_/X _2662_/A _2675_/B _2653_/A VPWR VGND sg13cmos5l_a21o_1
XFILLER_8_182 VPWR VGND sg13cmos5l_decap_8
X_2585_ _2585_/X _3005_/Q hold385/X _2589_/S VPWR VGND sg13cmos5l_mux2_1
X_1605_ _1610_/B _1638_/A _1638_/B _1638_/D VPWR VGND sg13cmos5l_nand3_1
X_1536_ _1740_/A _1535_/A _2368_/A VPWR VGND sg13cmos5l_nand2b_1
Xfanout128 _1500_/A _2855_/A VPWR VGND sg13cmos5l_buf_1
Xfanout106 _2412_/C _2371_/C VPWR VGND sg13cmos5l_buf_1
Xfanout117 _2272_/C _2047_/C VPWR VGND sg13cmos5l_buf_1
Xfanout139 _2183_/A _3017_/Q VPWR VGND sg13cmos5l_buf_1
XFILLER_27_215 VPWR VGND sg13cmos5l_fill_2
XFILLER_43_708 VPWR VGND sg13cmos5l_decap_8
XFILLER_36_782 VPWR VGND sg13cmos5l_decap_8
X_3068_ _3068_/Q _3072_/CLK _3068_/D fanout170/X VPWR VGND sg13cmos5l_dfrbpq_1
XFILLER_35_270 VPWR VGND sg13cmos5l_fill_1
X_2019_ _2077_/B _2267_/A _2169_/B _2323_/A VPWR VGND sg13cmos5l_a21oi_1
XFILLER_23_421 VPWR VGND sg13cmos5l_decap_8
XFILLER_24_944 VPWR VGND sg13cmos5l_decap_8
XFILLER_11_605 VPWR VGND sg13cmos5l_decap_8
XFILLER_12_55 VPWR VGND sg13cmos5l_fill_2
XFILLER_3_826 VPWR VGND sg13cmos5l_decap_8
XFILLER_2_303 VPWR VGND sg13cmos5l_decap_8
XFILLER_2_369 VPWR VGND sg13cmos5l_decap_8
XFILLER_19_716 VPWR VGND sg13cmos5l_decap_8
XFILLER_15_900 VPWR VGND sg13cmos5l_decap_8
XFILLER_14_410 VPWR VGND sg13cmos5l_fill_1
XFILLER_14_432 VPWR VGND sg13cmos5l_decap_8
XFILLER_27_782 VPWR VGND sg13cmos5l_decap_8
XFILLER_14_443 VPWR VGND sg13cmos5l_fill_2
XFILLER_14_454 VPWR VGND sg13cmos5l_decap_4
XFILLER_14_465 VPWR VGND sg13cmos5l_fill_2
XFILLER_15_977 VPWR VGND sg13cmos5l_decap_8
XFILLER_18_1027 VPWR VGND sg13cmos5l_fill_2
XFILLER_41_273 VPWR VGND sg13cmos5l_decap_8
XFILLER_30_925 VPWR VGND sg13cmos5l_decap_8
XFILLER_10_660 VPWR VGND sg13cmos5l_decap_8
XFILLER_6_697 VPWR VGND sg13cmos5l_decap_8
X_2370_ _2373_/A _2370_/A _2370_/B VPWR VGND sg13cmos5l_nand2_1
XFILLER_37_513 VPWR VGND sg13cmos5l_decap_8
XFILLER_25_708 VPWR VGND sg13cmos5l_decap_8
XFILLER_24_207 VPWR VGND sg13cmos5l_decap_4
XFILLER_18_782 VPWR VGND sg13cmos5l_decap_8
XFILLER_24_229 VPWR VGND sg13cmos5l_decap_8
XFILLER_32_273 VPWR VGND sg13cmos5l_decap_8
XFILLER_21_969 VPWR VGND sg13cmos5l_decap_8
XFILLER_20_468 VPWR VGND sg13cmos5l_fill_1
X_2706_ _2710_/A _3036_/Q _2717_/B VPWR VGND sg13cmos5l_xnor2_1
X_2637_ _3029_/D _2636_/Y _2464_/B _2637_/S VPWR VGND sg13cmos5l_mux2_1
X_2568_ _2570_/B _2568_/A _2568_/B _2568_/C _2568_/D VPWR VGND sg13cmos5l_nor4_1
X_2499_ _2967_/B _2515_/A _2499_/B _2499_/C _2499_/D VPWR VGND sg13cmos5l_nand4_1
X_1519_ _2339_/A _3124_/Q VPWR VGND sg13cmos5l_inv_1
XFILLER_28_579 VPWR VGND sg13cmos5l_decap_8
XFILLER_36_590 VPWR VGND sg13cmos5l_fill_1
XFILLER_24_752 VPWR VGND sg13cmos5l_fill_2
XFILLER_12_947 VPWR VGND sg13cmos5l_decap_8
XFILLER_8_907 VPWR VGND sg13cmos5l_decap_8
XFILLER_7_406 VPWR VGND sg13cmos5l_decap_8
XFILLER_11_435 VPWR VGND sg13cmos5l_decap_4
XFILLER_7_417 VPWR VGND sg13cmos5l_fill_2
XFILLER_11_468 VPWR VGND sg13cmos5l_fill_1
XFILLER_20_980 VPWR VGND sg13cmos5l_decap_8
XFILLER_23_65 VPWR VGND sg13cmos5l_decap_8
XFILLER_3_612 VPWR VGND sg13cmos5l_decap_8
XFILLER_47_800 VPWR VGND sg13cmos5l_decap_8
XFILLER_19_524 VPWR VGND sg13cmos5l_decap_8
XFILLER_0_14 VPWR VGND sg13cmos5l_decap_8
XFILLER_47_888 VPWR VGND sg13cmos5l_decap_8
XFILLER_19_579 VPWR VGND sg13cmos5l_decap_8
XFILLER_34_538 VPWR VGND sg13cmos5l_decap_8
XFILLER_14_240 VPWR VGND sg13cmos5l_fill_2
XFILLER_42_571 VPWR VGND sg13cmos5l_decap_8
X_1870_ _1908_/C _2244_/A _1870_/B VPWR VGND sg13cmos5l_nor2_1
XFILLER_9_78 VPWR VGND sg13cmos5l_decap_8
XFILLER_9_89 VPWR VGND sg13cmos5l_fill_2
XFILLER_7_951 VPWR VGND sg13cmos5l_decap_8
XFILLER_9_1003 VPWR VGND sg13cmos5l_decap_8
X_2422_ _3113_/D _2422_/A VPWR VGND sg13cmos5l_inv_1
X_2353_ _2353_/X _3025_/Q _2352_/Y _2353_/S VPWR VGND sg13cmos5l_mux2_1
X_2284_ _2327_/B _2370_/A _2284_/B _2284_/C _2284_/D VPWR VGND sg13cmos5l_nand4_1
XFILLER_38_844 VPWR VGND sg13cmos5l_decap_8
XFILLER_37_365 VPWR VGND sg13cmos5l_fill_1
XFILLER_25_549 VPWR VGND sg13cmos5l_fill_2
XFILLER_33_571 VPWR VGND sg13cmos5l_fill_1
XFILLER_21_755 VPWR VGND sg13cmos5l_fill_2
XFILLER_20_265 VPWR VGND sg13cmos5l_decap_8
XFILLER_21_799 VPWR VGND sg13cmos5l_decap_8
X_1999_ _1999_/Y _2147_/A _1971_/B _2205_/A VPWR VGND sg13cmos5l_a21oi_1
XFILLER_29_811 VPWR VGND sg13cmos5l_decap_8
XFILLER_28_310 VPWR VGND sg13cmos5l_decap_8
XFILLER_18_76 VPWR VGND sg13cmos5l_decap_4
XFILLER_29_888 VPWR VGND sg13cmos5l_decap_8
XFILLER_43_335 VPWR VGND sg13cmos5l_decap_4
XFILLER_18_98 VPWR VGND sg13cmos5l_decap_8
XFILLER_28_376 VPWR VGND sg13cmos5l_decap_8
XFILLER_44_869 VPWR VGND sg13cmos5l_decap_8
XFILLER_31_508 VPWR VGND sg13cmos5l_decap_8
XFILLER_8_704 VPWR VGND sg13cmos5l_decap_8
XFILLER_15_1019 VPWR VGND sg13cmos5l_decap_8
XFILLER_34_86 VPWR VGND sg13cmos5l_fill_1
XFILLER_34_97 VPWR VGND sg13cmos5l_fill_2
XFILLER_7_269 VPWR VGND sg13cmos5l_decap_4
XFILLER_4_965 VPWR VGND sg13cmos5l_decap_8
XFILLER_3_453 VPWR VGND sg13cmos5l_fill_2
XFILLER_3_464 VPWR VGND sg13cmos5l_fill_2
XFILLER_39_619 VPWR VGND sg13cmos5l_decap_4
XFILLER_19_310 VPWR VGND sg13cmos5l_decap_4
Xclkbuf_4_11_0_clk clkbuf_4_11_0_clk/X clkbuf_0_clk/X VPWR VGND sg13cmos5l_buf_8
XFILLER_35_836 VPWR VGND sg13cmos5l_decap_8
XFILLER_19_376 VPWR VGND sg13cmos5l_decap_8
XFILLER_34_346 VPWR VGND sg13cmos5l_fill_2
XFILLER_15_560 VPWR VGND sg13cmos5l_decap_8
X_2971_ _2971_/Q _3013_/CLK _2971_/D fanout160/X VPWR VGND sg13cmos5l_dfrbpq_1
X_1922_ _1922_/Y _1904_/Y _1921_/Y _2322_/A VPWR VGND sg13cmos5l_o21ai_1
X_1853_ _1853_/Y _1870_/B _2041_/B VPWR VGND sg13cmos5l_nor2_1
XFILLER_30_563 VPWR VGND sg13cmos5l_decap_4
X_1784_ _2927_/A _2919_/A _2669_/B VPWR VGND sg13cmos5l_nand2b_1
XFILLER_41_0 VPWR VGND sg13cmos5l_decap_8
X_2405_ _2410_/C _2414_/B VPWR VGND sg13cmos5l_inv_1
X_2336_ _2338_/C _2336_/A _2336_/B VPWR VGND sg13cmos5l_xnor2_1
XFILLER_38_630 VPWR VGND sg13cmos5l_decap_8
X_2267_ _2286_/C _2267_/A _2267_/B VPWR VGND sg13cmos5l_nor2_1
X_2198_ _2199_/D _2191_/Y _2197_/Y _2263_/A VPWR VGND sg13cmos5l_o21ai_1
XFILLER_25_335 VPWR VGND sg13cmos5l_decap_8
XFILLER_26_869 VPWR VGND sg13cmos5l_fill_1
XFILLER_41_828 VPWR VGND sg13cmos5l_fill_1
XFILLER_41_817 VPWR VGND sg13cmos5l_decap_8
XFILLER_40_316 VPWR VGND sg13cmos5l_decap_4
XFILLER_13_508 VPWR VGND sg13cmos5l_fill_2
XFILLER_21_552 VPWR VGND sg13cmos5l_decap_8
XFILLER_20_11 VPWR VGND sg13cmos5l_decap_8
XFILLER_20_99 VPWR VGND sg13cmos5l_decap_8
XFILLER_1_968 VPWR VGND sg13cmos5l_decap_8
XFILLER_0_467 VPWR VGND sg13cmos5l_decap_8
XFILLER_28_140 VPWR VGND sg13cmos5l_decap_8
XFILLER_44_611 VPWR VGND sg13cmos5l_decap_8
XFILLER_16_302 VPWR VGND sg13cmos5l_decap_4
XFILLER_16_313 VPWR VGND sg13cmos5l_decap_8
XFILLER_44_644 VPWR VGND sg13cmos5l_fill_1
XFILLER_32_806 VPWR VGND sg13cmos5l_decap_8
XFILLER_44_677 VPWR VGND sg13cmos5l_decap_8
XFILLER_12_530 VPWR VGND sg13cmos5l_decap_8
XFILLER_25_891 VPWR VGND sg13cmos5l_decap_8
XFILLER_31_349 VPWR VGND sg13cmos5l_fill_1
XFILLER_40_861 VPWR VGND sg13cmos5l_decap_4
XFILLER_12_541 VPWR VGND sg13cmos5l_fill_1
XFILLER_8_523 VPWR VGND sg13cmos5l_decap_8
XFILLER_8_556 VPWR VGND sg13cmos5l_decap_8
XFILLER_6_13 VPWR VGND sg13cmos5l_decap_8
XFILLER_4_762 VPWR VGND sg13cmos5l_decap_8
XFILLER_3_250 VPWR VGND sg13cmos5l_decap_8
XFILLER_3_283 VPWR VGND sg13cmos5l_decap_8
XFILLER_6_1028 VPWR VGND sg13cmos5l_fill_1
XFILLER_13_4 VPWR VGND sg13cmos5l_decap_8
X_2121_ _2121_/Y _2121_/A _2121_/B VPWR VGND sg13cmos5l_xnor2_1
X_2052_ _2055_/A _2052_/A _2052_/B VPWR VGND sg13cmos5l_nand2_1
XFILLER_35_622 VPWR VGND sg13cmos5l_decap_8
XFILLER_23_806 VPWR VGND sg13cmos5l_decap_8
XFILLER_34_132 VPWR VGND sg13cmos5l_fill_1
XFILLER_23_817 VPWR VGND sg13cmos5l_fill_1
XFILLER_23_839 VPWR VGND sg13cmos5l_fill_2
XFILLER_34_165 VPWR VGND sg13cmos5l_decap_8
XFILLER_15_390 VPWR VGND sg13cmos5l_decap_8
X_2954_ _2954_/Y _2923_/Y _2953_/Y hold404/X VPWR VGND sg13cmos5l_a21oi_1
X_1905_ _2029_/B _1861_/A _1862_/B _1972_/C _1836_/C _2183_/B VPWR VGND sg13cmos5l_a221oi_1
X_2885_ _2885_/Y _2885_/A _2885_/B VPWR VGND sg13cmos5l_xnor2_1
X_1836_ _2253_/A _1844_/A _1836_/B _1836_/C VPWR VGND sg13cmos5l_nand3_1
X_1767_ _1767_/Y _3120_/Q _1767_/B VPWR VGND sg13cmos5l_nand2_1
X_1698_ _1698_/Y _1698_/A _1698_/B _1698_/C VPWR VGND sg13cmos5l_nor3_1
XFILLER_44_1023 VPWR VGND sg13cmos5l_decap_4
X_2319_ _2319_/Y _2131_/B _2251_/C _2202_/Y VPWR VGND sg13cmos5l_a21oi_1
XFILLER_39_961 VPWR VGND sg13cmos5l_decap_8
XFILLER_26_611 VPWR VGND sg13cmos5l_decap_4
XFILLER_26_622 VPWR VGND sg13cmos5l_fill_2
XFILLER_26_633 VPWR VGND sg13cmos5l_fill_2
XFILLER_26_666 VPWR VGND sg13cmos5l_decap_8
XFILLER_40_135 VPWR VGND sg13cmos5l_decap_8
XFILLER_13_349 VPWR VGND sg13cmos5l_fill_2
XFILLER_15_33 VPWR VGND sg13cmos5l_fill_1
XFILLER_15_66 VPWR VGND sg13cmos5l_decap_8
XFILLER_22_861 VPWR VGND sg13cmos5l_decap_8
Xoutput8 uo_out[4] _3159_/X VPWR VGND sg13cmos5l_buf_1
XFILLER_0_242 VPWR VGND sg13cmos5l_fill_2
XFILLER_1_765 VPWR VGND sg13cmos5l_decap_8
XFILLER_0_297 VPWR VGND sg13cmos5l_decap_8
XFILLER_49_769 VPWR VGND sg13cmos5l_decap_8
XFILLER_29_460 VPWR VGND sg13cmos5l_fill_1
XFILLER_16_121 VPWR VGND sg13cmos5l_decap_4
XFILLER_45_975 VPWR VGND sg13cmos5l_decap_8
XFILLER_44_463 VPWR VGND sg13cmos5l_decap_8
XFILLER_16_154 VPWR VGND sg13cmos5l_fill_1
XFILLER_44_496 VPWR VGND sg13cmos5l_decap_8
XFILLER_16_187 VPWR VGND sg13cmos5l_decap_8
XFILLER_31_102 VPWR VGND sg13cmos5l_decap_8
XFILLER_9_821 VPWR VGND sg13cmos5l_decap_8
XFILLER_13_883 VPWR VGND sg13cmos5l_decap_8
X_2670_ _2671_/C _2473_/A _2442_/C _2442_/A VPWR VGND sg13cmos5l_a21oi_1
XFILLER_8_364 VPWR VGND sg13cmos5l_decap_8
XFILLER_12_393 VPWR VGND sg13cmos5l_decap_8
XFILLER_9_898 VPWR VGND sg13cmos5l_decap_8
X_1621_ _1720_/B _1726_/B _1646_/C VPWR VGND sg13cmos5l_nand2_1
X_1552_ _1571_/B _1575_/A _1550_/Y _1541_/Y VPWR VGND sg13cmos5l_o21ai_1
XFILLER_28_1007 VPWR VGND sg13cmos5l_decap_8
X_1483_ _2594_/A _1862_/B VPWR VGND sg13cmos5l_inv_1
XFILLER_39_246 VPWR VGND sg13cmos5l_decap_8
X_2104_ _2116_/A _2098_/A _2103_/Y _2263_/A VPWR VGND sg13cmos5l_o21ai_1
XFILLER_28_909 VPWR VGND sg13cmos5l_decap_8
X_3084_ _3084_/Q _3085_/CLK _3084_/D fanout165/X VPWR VGND sg13cmos5l_dfrbpq_1
XFILLER_36_964 VPWR VGND sg13cmos5l_decap_8
X_2035_ _2035_/Y _2294_/A _2035_/B _2135_/B VPWR VGND sg13cmos5l_nor3_1
XFILLER_35_485 VPWR VGND sg13cmos5l_decap_4
XFILLER_23_636 VPWR VGND sg13cmos5l_decap_8
X_2937_ _2939_/B _3035_/Q _2948_/B VPWR VGND sg13cmos5l_xnor2_1
XFILLER_30_190 VPWR VGND sg13cmos5l_decap_4
X_2868_ _2880_/D _2869_/A _2869_/B VPWR VGND sg13cmos5l_nor2_1
Xhold320 _2840_/B _2838_/Y VPWR VGND sg13cmos5l_dlygate4sd3_1
X_2799_ _2803_/D _3030_/Q _3046_/Q VPWR VGND sg13cmos5l_xnor2_1
X_1819_ _3127_/D _1821_/B _2339_/B _1819_/C VPWR VGND sg13cmos5l_nor3_1
Xhold331 _2827_/A _3054_/Q VPWR VGND sg13cmos5l_dlygate4sd3_1
Xhold342 _2845_/A _3060_/Q VPWR VGND sg13cmos5l_dlygate4sd3_1
Xhold353 _2577_/A _3007_/Q VPWR VGND sg13cmos5l_dlygate4sd3_1
Xhold386 _3005_/D _2585_/X VPWR VGND sg13cmos5l_dlygate4sd3_1
Xhold364 hold364/X _2972_/Q VPWR VGND sg13cmos5l_dlygate4sd3_1
Xhold375 _3065_/D _2861_/Y VPWR VGND sg13cmos5l_dlygate4sd3_1
Xhold397 _2545_/A _2991_/Q VPWR VGND sg13cmos5l_dlygate4sd3_1
XFILLER_46_717 VPWR VGND sg13cmos5l_decap_8
XFILLER_19_909 VPWR VGND sg13cmos5l_decap_8
XFILLER_39_780 VPWR VGND sg13cmos5l_decap_8
XFILLER_27_920 VPWR VGND sg13cmos5l_decap_8
XFILLER_45_249 VPWR VGND sg13cmos5l_fill_1
XFILLER_26_32 VPWR VGND sg13cmos5l_decap_8
Xclkbuf_5_23__f_clk _3129_/CLK clkbuf_4_11_0_clk/X VPWR VGND sg13cmos5l_buf_8
XFILLER_14_614 VPWR VGND sg13cmos5l_fill_1
XFILLER_27_997 VPWR VGND sg13cmos5l_decap_8
XFILLER_42_945 VPWR VGND sg13cmos5l_decap_8
XFILLER_26_76 VPWR VGND sg13cmos5l_decap_8
XFILLER_41_466 VPWR VGND sg13cmos5l_decap_4
XFILLER_41_455 VPWR VGND sg13cmos5l_fill_2
XFILLER_14_669 VPWR VGND sg13cmos5l_decap_8
XFILLER_41_499 VPWR VGND sg13cmos5l_fill_2
XFILLER_41_488 VPWR VGND sg13cmos5l_decap_8
XFILLER_13_168 VPWR VGND sg13cmos5l_decap_8
XFILLER_42_86 VPWR VGND sg13cmos5l_decap_8
XFILLER_6_802 VPWR VGND sg13cmos5l_decap_8
XFILLER_6_879 VPWR VGND sg13cmos5l_decap_8
XFILLER_5_345 VPWR VGND sg13cmos5l_fill_1
XFILLER_5_378 VPWR VGND sg13cmos5l_decap_8
XFILLER_49_522 VPWR VGND sg13cmos5l_decap_8
XFILLER_3_58 VPWR VGND sg13cmos5l_decap_4
XFILLER_1_573 VPWR VGND sg13cmos5l_decap_4
XFILLER_49_566 VPWR VGND sg13cmos5l_decap_4
XFILLER_18_964 VPWR VGND sg13cmos5l_decap_8
XFILLER_29_290 VPWR VGND sg13cmos5l_decap_8
XFILLER_17_441 VPWR VGND sg13cmos5l_decap_4
XFILLER_17_474 VPWR VGND sg13cmos5l_decap_8
XFILLER_32_422 VPWR VGND sg13cmos5l_decap_8
XFILLER_33_956 VPWR VGND sg13cmos5l_decap_8
XFILLER_44_293 VPWR VGND sg13cmos5l_fill_1
XFILLER_20_617 VPWR VGND sg13cmos5l_decap_4
XFILLER_34_1022 VPWR VGND sg13cmos5l_decap_8
X_2722_ _2723_/A hold432/X _2747_/A _2720_/X _2721_/Y VPWR VGND sg13cmos5l_a22oi_1
XFILLER_9_640 VPWR VGND sg13cmos5l_decap_8
XFILLER_13_691 VPWR VGND sg13cmos5l_decap_8
XFILLER_9_695 VPWR VGND sg13cmos5l_decap_8
X_2653_ _2655_/A _2653_/A _2662_/A _2675_/B VPWR VGND sg13cmos5l_and3_1
X_2584_ _3004_/D _2572_/A _2574_/A _2592_/S VPWR VGND sg13cmos5l_mux2_1
X_1604_ _1608_/C _1604_/A _1604_/B VPWR VGND sg13cmos5l_nor2_1
X_1535_ _1722_/A _1535_/A _2368_/A VPWR VGND sg13cmos5l_nor2b_1
Xfanout129 _2730_/A1 _2855_/A VPWR VGND sg13cmos5l_buf_1
Xfanout118 _2047_/C _2242_/A VPWR VGND sg13cmos5l_buf_1
Xfanout107 _2404_/B hold453/X VPWR VGND sg13cmos5l_buf_1
XFILLER_41_1015 VPWR VGND sg13cmos5l_decap_8
X_3136_ _3136_/Q _3136_/CLK _3136_/D fanout168/X VPWR VGND sg13cmos5l_dfrbpq_1
XFILLER_28_739 VPWR VGND sg13cmos5l_decap_8
X_3067_ _3067_/Q _3093_/CLK _3067_/D fanout169/X VPWR VGND sg13cmos5l_dfrbpq_1
XFILLER_36_761 VPWR VGND sg13cmos5l_decap_8
X_2018_ _2089_/B _2017_/Y _2404_/B VPWR VGND sg13cmos5l_nand2b_1
XFILLER_23_400 VPWR VGND sg13cmos5l_decap_4
XFILLER_24_923 VPWR VGND sg13cmos5l_decap_8
XFILLER_23_455 VPWR VGND sg13cmos5l_decap_4
XFILLER_10_105 VPWR VGND sg13cmos5l_decap_8
XFILLER_11_628 VPWR VGND sg13cmos5l_decap_8
XFILLER_12_34 VPWR VGND sg13cmos5l_decap_4
XFILLER_3_805 VPWR VGND sg13cmos5l_decap_8
XFILLER_2_337 VPWR VGND sg13cmos5l_decap_8
XFILLER_2_348 VPWR VGND sg13cmos5l_fill_2
XFILLER_18_205 VPWR VGND sg13cmos5l_fill_2
XFILLER_2_1020 VPWR VGND sg13cmos5l_decap_8
XFILLER_37_86 VPWR VGND sg13cmos5l_decap_8
XFILLER_33_208 VPWR VGND sg13cmos5l_decap_8
XFILLER_15_956 VPWR VGND sg13cmos5l_decap_8
XFILLER_18_1006 VPWR VGND sg13cmos5l_decap_8
XFILLER_30_904 VPWR VGND sg13cmos5l_decap_8
XFILLER_14_488 VPWR VGND sg13cmos5l_fill_1
XFILLER_10_683 VPWR VGND sg13cmos5l_decap_8
XFILLER_6_676 VPWR VGND sg13cmos5l_decap_8
XFILLER_49_352 VPWR VGND sg13cmos5l_decap_8
XFILLER_49_385 VPWR VGND sg13cmos5l_decap_8
XFILLER_37_569 VPWR VGND sg13cmos5l_fill_2
XFILLER_18_761 VPWR VGND sg13cmos5l_decap_8
XFILLER_45_591 VPWR VGND sg13cmos5l_decap_8
XFILLER_17_282 VPWR VGND sg13cmos5l_fill_2
XFILLER_20_403 VPWR VGND sg13cmos5l_decap_4
XFILLER_21_948 VPWR VGND sg13cmos5l_decap_8
XFILLER_20_447 VPWR VGND sg13cmos5l_decap_8
X_2705_ _2726_/A _3036_/Q _2717_/B VPWR VGND sg13cmos5l_and2_1
XFILLER_9_481 VPWR VGND sg13cmos5l_decap_4
X_2636_ _2636_/Y _2672_/A _2636_/B VPWR VGND sg13cmos5l_xnor2_1
X_2567_ _2568_/D _2567_/A _2567_/B VPWR VGND sg13cmos5l_xnor2_1
X_1518_ _2515_/A _2498_/A VPWR VGND sg13cmos5l_inv_1
X_2498_ _2500_/B _2498_/A _2499_/B _2499_/C _2499_/D VPWR VGND sg13cmos5l_nand4_1
XFILLER_28_503 VPWR VGND sg13cmos5l_decap_8
XFILLER_43_506 VPWR VGND sg13cmos5l_fill_1
X_3119_ _3119_/Q _3119_/CLK _3119_/D fanout150/X VPWR VGND sg13cmos5l_dfrbpq_1
XFILLER_15_219 VPWR VGND sg13cmos5l_fill_1
XFILLER_11_414 VPWR VGND sg13cmos5l_decap_4
XFILLER_12_926 VPWR VGND sg13cmos5l_decap_8
XFILLER_23_11 VPWR VGND sg13cmos5l_decap_8
XFILLER_23_274 VPWR VGND sg13cmos5l_decap_8
XFILLER_23_22 VPWR VGND sg13cmos5l_fill_1
XFILLER_23_55 VPWR VGND sg13cmos5l_fill_2
XFILLER_2_101 VPWR VGND sg13cmos5l_fill_1
XFILLER_3_679 VPWR VGND sg13cmos5l_decap_8
XFILLER_24_1021 VPWR VGND sg13cmos5l_decap_8
XFILLER_48_63 VPWR VGND sg13cmos5l_decap_8
XFILLER_47_867 VPWR VGND sg13cmos5l_decap_8
XFILLER_46_344 VPWR VGND sg13cmos5l_fill_2
XFILLER_34_506 VPWR VGND sg13cmos5l_fill_2
XFILLER_15_720 VPWR VGND sg13cmos5l_decap_8
XFILLER_27_580 VPWR VGND sg13cmos5l_fill_1
XFILLER_15_797 VPWR VGND sg13cmos5l_decap_8
XFILLER_9_46 VPWR VGND sg13cmos5l_decap_4
XFILLER_9_57 VPWR VGND sg13cmos5l_decap_8
XFILLER_30_767 VPWR VGND sg13cmos5l_fill_1
XFILLER_7_930 VPWR VGND sg13cmos5l_decap_8
XFILLER_10_480 VPWR VGND sg13cmos5l_decap_4
XFILLER_11_992 VPWR VGND sg13cmos5l_decap_8
XFILLER_31_1025 VPWR VGND sg13cmos5l_decap_4
XFILLER_6_462 VPWR VGND sg13cmos5l_decap_8
XFILLER_10_491 VPWR VGND sg13cmos5l_decap_8
XFILLER_6_473 VPWR VGND sg13cmos5l_fill_1
X_2421_ _2422_/A _2371_/B _2419_/A _2420_/Y VPWR VGND sg13cmos5l_o21ai_1
X_2352_ _2352_/Y _2392_/A _1520_/Y _2351_/Y VPWR VGND sg13cmos5l_a21oi_1
X_2283_ _2284_/D _2274_/Y _2282_/Y _2281_/A VPWR VGND sg13cmos5l_o21ai_1
XFILLER_37_300 VPWR VGND sg13cmos5l_fill_2
XFILLER_49_193 VPWR VGND sg13cmos5l_decap_8
XFILLER_38_834 VPWR VGND sg13cmos5l_fill_1
XFILLER_37_344 VPWR VGND sg13cmos5l_decap_8
XFILLER_37_399 VPWR VGND sg13cmos5l_decap_8
XFILLER_25_528 VPWR VGND sg13cmos5l_decap_8
XFILLER_21_712 VPWR VGND sg13cmos5l_fill_1
XFILLER_20_244 VPWR VGND sg13cmos5l_decap_8
X_1998_ _2001_/B _2148_/B _2251_/B _1997_/Y VPWR VGND sg13cmos5l_o21ai_1
XFILLER_47_1021 VPWR VGND sg13cmos5l_decap_8
X_2619_ _2630_/B _3023_/Q _2619_/B VPWR VGND sg13cmos5l_nor2_1
XFILLER_0_649 VPWR VGND sg13cmos5l_decap_8
XFILLER_29_867 VPWR VGND sg13cmos5l_decap_8
XFILLER_44_848 VPWR VGND sg13cmos5l_decap_8
XFILLER_34_21 VPWR VGND sg13cmos5l_decap_4
XFILLER_34_54 VPWR VGND sg13cmos5l_decap_8
XFILLER_11_222 VPWR VGND sg13cmos5l_decap_8
XFILLER_12_745 VPWR VGND sg13cmos5l_decap_8
XFILLER_12_778 VPWR VGND sg13cmos5l_fill_2
XFILLER_7_248 VPWR VGND sg13cmos5l_decap_8
XFILLER_4_944 VPWR VGND sg13cmos5l_decap_8
XFILLER_3_432 VPWR VGND sg13cmos5l_decap_8
XFILLER_3_498 VPWR VGND sg13cmos5l_decap_8
XFILLER_19_355 VPWR VGND sg13cmos5l_decap_8
XFILLER_47_686 VPWR VGND sg13cmos5l_decap_8
XFILLER_46_152 VPWR VGND sg13cmos5l_fill_2
XFILLER_46_196 VPWR VGND sg13cmos5l_decap_4
X_2970_ _2970_/Q clkload1/A _2970_/D fanout159/X VPWR VGND sg13cmos5l_dfrbpq_1
XFILLER_43_892 VPWR VGND sg13cmos5l_decap_8
X_1921_ _1921_/Y _1915_/Y _1918_/Y _1912_/Y VPWR VGND sg13cmos5l_a21oi_1
X_1852_ _2599_/A _2244_/B _1852_/B VPWR VGND sg13cmos5l_nand2_1
XFILLER_30_542 VPWR VGND sg13cmos5l_decap_8
X_1783_ _1783_/Y _2919_/A _2669_/B VPWR VGND sg13cmos5l_nor2b_1
X_2404_ _2414_/B _2404_/A _2404_/B _2404_/C VPWR VGND sg13cmos5l_nand3_1
XFILLER_34_0 VPWR VGND sg13cmos5l_decap_8
X_2335_ _2337_/B _2596_/A _3113_/Q _2335_/C _2440_/B VPWR VGND sg13cmos5l_nor4_1
X_2266_ _2267_/B _2266_/A _2266_/B VPWR VGND sg13cmos5l_nor2_1
XFILLER_37_141 VPWR VGND sg13cmos5l_fill_1
X_2197_ _2197_/Y _2197_/A _2197_/B _2197_/C VPWR VGND sg13cmos5l_nand3_1
Xclkbuf_5_4__f_clk _3122_/CLK clkbuf_4_2_0_clk/X VPWR VGND sg13cmos5l_buf_8
XFILLER_38_686 VPWR VGND sg13cmos5l_decap_8
XFILLER_26_826 VPWR VGND sg13cmos5l_decap_8
XFILLER_38_1009 VPWR VGND sg13cmos5l_decap_8
XFILLER_25_358 VPWR VGND sg13cmos5l_decap_8
XFILLER_21_531 VPWR VGND sg13cmos5l_decap_8
XFILLER_4_229 VPWR VGND sg13cmos5l_decap_8
XFILLER_20_78 VPWR VGND sg13cmos5l_decap_8
XFILLER_0_446 VPWR VGND sg13cmos5l_decap_8
XFILLER_1_947 VPWR VGND sg13cmos5l_decap_8
XFILLER_29_32 VPWR VGND sg13cmos5l_fill_2
XFILLER_29_620 VPWR VGND sg13cmos5l_fill_2
XFILLER_29_642 VPWR VGND sg13cmos5l_fill_2
XFILLER_44_601 VPWR VGND sg13cmos5l_fill_1
XFILLER_17_815 VPWR VGND sg13cmos5l_decap_8
XFILLER_17_848 VPWR VGND sg13cmos5l_decap_8
XFILLER_45_64 VPWR VGND sg13cmos5l_fill_2
XFILLER_44_667 VPWR VGND sg13cmos5l_decap_4
XFILLER_43_133 VPWR VGND sg13cmos5l_fill_1
XFILLER_16_358 VPWR VGND sg13cmos5l_decap_4
XFILLER_28_196 VPWR VGND sg13cmos5l_fill_2
XFILLER_45_97 VPWR VGND sg13cmos5l_decap_8
XFILLER_8_502 VPWR VGND sg13cmos5l_decap_4
XFILLER_6_69 VPWR VGND sg13cmos5l_decap_8
XFILLER_4_741 VPWR VGND sg13cmos5l_decap_8
XFILLER_39_417 VPWR VGND sg13cmos5l_decap_8
X_2120_ _2121_/B _2076_/A _2072_/B _2266_/A VPWR VGND sg13cmos5l_a21oi_1
XFILLER_47_450 VPWR VGND sg13cmos5l_decap_8
X_2051_ _2052_/B _2273_/A _2051_/B _2051_/C _2051_/D VPWR VGND sg13cmos5l_nand4_1
XFILLER_48_984 VPWR VGND sg13cmos5l_decap_8
XFILLER_47_483 VPWR VGND sg13cmos5l_decap_8
XFILLER_19_152 VPWR VGND sg13cmos5l_fill_2
XFILLER_19_196 VPWR VGND sg13cmos5l_decap_4
XFILLER_16_870 VPWR VGND sg13cmos5l_decap_4
XFILLER_34_144 VPWR VGND sg13cmos5l_decap_8
X_2953_ _2953_/Y _2953_/A _2953_/B _2953_/C VPWR VGND sg13cmos5l_nor3_1
XFILLER_16_881 VPWR VGND sg13cmos5l_decap_8
XFILLER_22_328 VPWR VGND sg13cmos5l_decap_8
XFILLER_34_188 VPWR VGND sg13cmos5l_fill_1
X_1904_ _1904_/Y _1882_/Y _1903_/Y _2113_/A VPWR VGND sg13cmos5l_a21oi_1
X_2884_ _2889_/B _2885_/A _2885_/B VPWR VGND sg13cmos5l_nor2_1
X_1835_ _1835_/X _1844_/A _1836_/B _1845_/B VPWR VGND sg13cmos5l_and3_1
X_1766_ _1767_/B _3118_/Q _3119_/Q VPWR VGND sg13cmos5l_nor2_1
XFILLER_7_590 VPWR VGND sg13cmos5l_fill_1
X_1697_ _1698_/C _1726_/A _1726_/C _1709_/B _1697_/D VPWR VGND sg13cmos5l_nor4_1
XFILLER_44_1002 VPWR VGND sg13cmos5l_decap_8
X_2318_ _2321_/A _2318_/A _2318_/B VPWR VGND sg13cmos5l_nor2_1
XFILLER_39_940 VPWR VGND sg13cmos5l_decap_8
X_2249_ _2249_/Y _2249_/A _2249_/B VPWR VGND sg13cmos5l_nand2_1
XFILLER_25_133 VPWR VGND sg13cmos5l_fill_1
XFILLER_26_645 VPWR VGND sg13cmos5l_decap_8
XFILLER_14_807 VPWR VGND sg13cmos5l_decap_8
XFILLER_41_626 VPWR VGND sg13cmos5l_fill_1
XFILLER_13_328 VPWR VGND sg13cmos5l_fill_2
XFILLER_25_199 VPWR VGND sg13cmos5l_decap_8
XFILLER_21_372 VPWR VGND sg13cmos5l_decap_8
Xclkbuf_4_10_0_clk clkbuf_4_10_0_clk/X clkbuf_0_clk/X VPWR VGND sg13cmos5l_buf_8
Xoutput9 uo_out[5] _3160_/X VPWR VGND sg13cmos5l_buf_1
XFILLER_0_221 VPWR VGND sg13cmos5l_decap_8
XFILLER_1_744 VPWR VGND sg13cmos5l_decap_8
XFILLER_49_748 VPWR VGND sg13cmos5l_decap_8
XFILLER_0_276 VPWR VGND sg13cmos5l_decap_8
XFILLER_45_954 VPWR VGND sg13cmos5l_decap_8
XFILLER_16_100 VPWR VGND sg13cmos5l_fill_2
XFILLER_17_634 VPWR VGND sg13cmos5l_decap_8
XFILLER_17_645 VPWR VGND sg13cmos5l_fill_2
XFILLER_29_494 VPWR VGND sg13cmos5l_decap_4
XFILLER_16_166 VPWR VGND sg13cmos5l_decap_4
XFILLER_32_637 VPWR VGND sg13cmos5l_decap_8
XFILLER_9_800 VPWR VGND sg13cmos5l_decap_8
XFILLER_31_136 VPWR VGND sg13cmos5l_decap_4
XFILLER_31_158 VPWR VGND sg13cmos5l_fill_1
XFILLER_40_692 VPWR VGND sg13cmos5l_decap_8
XFILLER_8_354 VPWR VGND sg13cmos5l_decap_4
XFILLER_9_877 VPWR VGND sg13cmos5l_decap_8
X_1620_ _1729_/B _1632_/A _1646_/D _1633_/B VPWR VGND sg13cmos5l_a21o_1
XFILLER_8_398 VPWR VGND sg13cmos5l_decap_8
X_1551_ _1575_/B _3133_/Q _2605_/B VPWR VGND sg13cmos5l_xnor2_1
X_1482_ _1482_/Y _3130_/Q VPWR VGND sg13cmos5l_inv_1
XFILLER_39_225 VPWR VGND sg13cmos5l_decap_8
X_2103_ _2103_/Y _2187_/A _2102_/Y _2032_/A VPWR VGND sg13cmos5l_a21oi_1
X_3083_ _3083_/Q _3103_/CLK _3083_/D fanout160/X VPWR VGND sg13cmos5l_dfrbpq_1
XFILLER_36_943 VPWR VGND sg13cmos5l_decap_8
X_2034_ _2052_/A _2028_/Y _2033_/Y _2077_/B VPWR VGND sg13cmos5l_o21ai_1
X_2936_ _2940_/C _3040_/Q _2926_/Y _2928_/Y VPWR VGND sg13cmos5l_o21ai_1
XFILLER_10_309 VPWR VGND sg13cmos5l_decap_8
XFILLER_31_681 VPWR VGND sg13cmos5l_fill_1
X_2867_ _2867_/Y _2867_/A _2879_/B VPWR VGND sg13cmos5l_nand2_1
X_1818_ _1819_/C _1818_/A _1818_/B VPWR VGND sg13cmos5l_nor2_1
X_2798_ _2800_/D _3036_/Q _3052_/Q VPWR VGND sg13cmos5l_xnor2_1
Xhold310 _2377_/B _3115_/Q VPWR VGND sg13cmos5l_dlygate4sd3_1
Xhold321 _3058_/D _2840_/Y VPWR VGND sg13cmos5l_dlygate4sd3_1
Xhold332 hold332/X _3083_/Q VPWR VGND sg13cmos5l_dlygate4sd3_1
Xhold343 _2614_/A _3022_/Q VPWR VGND sg13cmos5l_dlygate4sd3_1
X_1749_ _1749_/Y _2605_/A _1749_/B VPWR VGND sg13cmos5l_nor2_1
Xhold387 _2499_/B _2997_/Q VPWR VGND sg13cmos5l_dlygate4sd3_1
Xhold354 _2998_/D _2578_/Y VPWR VGND sg13cmos5l_dlygate4sd3_1
Xhold365 _2972_/D _2467_/X VPWR VGND sg13cmos5l_dlygate4sd3_1
Xhold376 _2872_/A _3068_/Q VPWR VGND sg13cmos5l_dlygate4sd3_1
Xhold398 _2547_/A _2546_/Y VPWR VGND sg13cmos5l_dlygate4sd3_1
XFILLER_26_11 VPWR VGND sg13cmos5l_decap_8
XFILLER_27_976 VPWR VGND sg13cmos5l_decap_8
XFILLER_42_924 VPWR VGND sg13cmos5l_decap_8
XFILLER_13_136 VPWR VGND sg13cmos5l_decap_8
XFILLER_14_659 VPWR VGND sg13cmos5l_fill_2
XFILLER_21_180 VPWR VGND sg13cmos5l_decap_8
XFILLER_22_681 VPWR VGND sg13cmos5l_decap_4
XFILLER_6_858 VPWR VGND sg13cmos5l_decap_8
XFILLER_5_324 VPWR VGND sg13cmos5l_fill_2
XFILLER_5_357 VPWR VGND sg13cmos5l_decap_8
XFILLER_49_501 VPWR VGND sg13cmos5l_decap_8
XFILLER_49_545 VPWR VGND sg13cmos5l_decap_8
XFILLER_36_217 VPWR VGND sg13cmos5l_fill_2
XFILLER_36_228 VPWR VGND sg13cmos5l_decap_4
XFILLER_17_431 VPWR VGND sg13cmos5l_fill_2
XFILLER_18_943 VPWR VGND sg13cmos5l_decap_8
XFILLER_45_751 VPWR VGND sg13cmos5l_decap_4
XFILLER_44_272 VPWR VGND sg13cmos5l_decap_8
XFILLER_33_935 VPWR VGND sg13cmos5l_decap_8
XFILLER_32_489 VPWR VGND sg13cmos5l_decap_8
XFILLER_34_1001 VPWR VGND sg13cmos5l_decap_8
X_2721_ _2721_/Y _2730_/A1 _1524_/Y _2730_/B1 VPWR VGND sg13cmos5l_a21oi_1
X_2652_ _2675_/B _2925_/A _2947_/B _2442_/C VPWR VGND sg13cmos5l_o21ai_1
XFILLER_8_195 VPWR VGND sg13cmos5l_decap_8
X_2583_ _2583_/X hold282/X _3004_/Q _2592_/S VPWR VGND sg13cmos5l_mux2_1
X_1603_ _1696_/C _1638_/B _1638_/D _1638_/A VPWR VGND sg13cmos5l_o21ai_1
X_1534_ _2368_/A _2980_/Q _2974_/Q _2976_/Q _2978_/Q _1527_/A _3122_/Q VPWR VGND sg13cmos5l_mux4_1
Xfanout119 _2242_/A _3104_/Q VPWR VGND sg13cmos5l_buf_1
Xfanout108 _2404_/A hold457/X VPWR VGND sg13cmos5l_buf_1
X_3135_ _3135_/Q _3135_/CLK _3135_/D fanout168/X VPWR VGND sg13cmos5l_dfrbpq_1
XFILLER_27_217 VPWR VGND sg13cmos5l_fill_1
XFILLER_28_718 VPWR VGND sg13cmos5l_decap_8
X_3066_ _3066_/Q _3093_/CLK _3066_/D fanout169/X VPWR VGND sg13cmos5l_dfrbpq_1
XFILLER_27_239 VPWR VGND sg13cmos5l_decap_8
X_2017_ _2017_/Y _1922_/Y _1965_/Y _2007_/Y _2016_/Y VPWR VGND sg13cmos5l_a22oi_1
XFILLER_24_902 VPWR VGND sg13cmos5l_decap_8
XFILLER_35_283 VPWR VGND sg13cmos5l_fill_2
XFILLER_35_261 VPWR VGND sg13cmos5l_decap_8
XFILLER_24_979 VPWR VGND sg13cmos5l_decap_8
XFILLER_23_489 VPWR VGND sg13cmos5l_decap_8
X_2919_ _2920_/B _2919_/A _2925_/A _2947_/B VPWR VGND sg13cmos5l_nor3_1
XFILLER_32_990 VPWR VGND sg13cmos5l_decap_8
XFILLER_12_57 VPWR VGND sg13cmos5l_fill_1
XFILLER_2_316 VPWR VGND sg13cmos5l_decap_8
XFILLER_19_729 VPWR VGND sg13cmos5l_decap_8
XFILLER_46_548 VPWR VGND sg13cmos5l_decap_8
XFILLER_37_65 VPWR VGND sg13cmos5l_decap_8
XFILLER_18_217 VPWR VGND sg13cmos5l_decap_8
XFILLER_18_228 VPWR VGND sg13cmos5l_fill_1
XFILLER_14_401 VPWR VGND sg13cmos5l_decap_8
XFILLER_15_935 VPWR VGND sg13cmos5l_decap_8
XFILLER_14_467 VPWR VGND sg13cmos5l_fill_1
XFILLER_6_655 VPWR VGND sg13cmos5l_decap_8
XFILLER_5_187 VPWR VGND sg13cmos5l_fill_2
XFILLER_38_7 VPWR VGND sg13cmos5l_decap_8
XFILLER_2_894 VPWR VGND sg13cmos5l_decap_8
XFILLER_49_331 VPWR VGND sg13cmos5l_decap_8
XFILLER_18_740 VPWR VGND sg13cmos5l_decap_8
XFILLER_45_570 VPWR VGND sg13cmos5l_decap_8
XFILLER_32_220 VPWR VGND sg13cmos5l_fill_1
XFILLER_20_415 VPWR VGND sg13cmos5l_fill_2
XFILLER_21_927 VPWR VGND sg13cmos5l_decap_8
XFILLER_20_437 VPWR VGND sg13cmos5l_fill_1
XFILLER_9_460 VPWR VGND sg13cmos5l_decap_8
XFILLER_20_459 VPWR VGND sg13cmos5l_decap_8
X_2704_ _3035_/D _2704_/A VPWR VGND sg13cmos5l_inv_1
X_2635_ _2636_/B _2635_/A _2635_/B VPWR VGND sg13cmos5l_nor2_1
X_2566_ _2568_/C _3003_/Q input2/X VPWR VGND sg13cmos5l_nand2b_1
X_1517_ _2512_/B _2503_/B VPWR VGND sg13cmos5l_inv_1
X_2497_ _2501_/C _2498_/A _2499_/B _2499_/D VPWR VGND sg13cmos5l_nand3_1
X_3118_ _3118_/Q _3119_/CLK _3118_/D fanout150/X VPWR VGND sg13cmos5l_dfrbpq_1
X_3049_ _3049_/Q _3050_/CLK _3049_/D fanout173/X VPWR VGND sg13cmos5l_dfrbpq_1
XFILLER_12_905 VPWR VGND sg13cmos5l_decap_8
XFILLER_23_242 VPWR VGND sg13cmos5l_decap_8
XFILLER_24_787 VPWR VGND sg13cmos5l_decap_8
XFILLER_23_34 VPWR VGND sg13cmos5l_decap_4
XFILLER_11_459 VPWR VGND sg13cmos5l_decap_8
XFILLER_3_658 VPWR VGND sg13cmos5l_decap_8
XFILLER_3_4 VPWR VGND sg13cmos5l_decap_4
XFILLER_2_157 VPWR VGND sg13cmos5l_decap_4
XFILLER_2_179 VPWR VGND sg13cmos5l_fill_2
XFILLER_24_1000 VPWR VGND sg13cmos5l_decap_8
XFILLER_47_846 VPWR VGND sg13cmos5l_decap_8
XFILLER_46_323 VPWR VGND sg13cmos5l_decap_8
XFILLER_46_312 VPWR VGND sg13cmos5l_decap_8
XFILLER_9_25 VPWR VGND sg13cmos5l_decap_8
XFILLER_15_776 VPWR VGND sg13cmos5l_decap_8
Xfanout90 _1845_/A _1972_/C VPWR VGND sg13cmos5l_buf_1
XFILLER_31_1004 VPWR VGND sg13cmos5l_decap_8
XFILLER_11_971 VPWR VGND sg13cmos5l_decap_8
XFILLER_7_986 VPWR VGND sg13cmos5l_decap_8
X_2420_ _2420_/Y _2371_/B _2419_/A _2594_/B VPWR VGND sg13cmos5l_a21oi_1
X_2351_ _2351_/Y _2392_/A _3026_/Q VPWR VGND sg13cmos5l_nor2_1
XFILLER_2_691 VPWR VGND sg13cmos5l_decap_8
X_2282_ _2282_/Y _2282_/A _2282_/B VPWR VGND sg13cmos5l_nor2_1
XFILLER_38_802 VPWR VGND sg13cmos5l_decap_8
XFILLER_49_172 VPWR VGND sg13cmos5l_decap_8
XFILLER_25_507 VPWR VGND sg13cmos5l_decap_8
XFILLER_46_890 VPWR VGND sg13cmos5l_decap_8
XFILLER_33_540 VPWR VGND sg13cmos5l_decap_8
XFILLER_33_551 VPWR VGND sg13cmos5l_fill_2
XFILLER_20_201 VPWR VGND sg13cmos5l_decap_8
XFILLER_20_223 VPWR VGND sg13cmos5l_decap_8
XFILLER_33_584 VPWR VGND sg13cmos5l_decap_8
XFILLER_33_595 VPWR VGND sg13cmos5l_fill_2
X_1997_ _1997_/Y _2063_/A _1887_/Y _1985_/B VPWR VGND sg13cmos5l_a21oi_1
XFILLER_21_757 VPWR VGND sg13cmos5l_fill_1
XFILLER_47_1000 VPWR VGND sg13cmos5l_decap_8
X_2618_ _3023_/D _2628_/B _2618_/B VPWR VGND sg13cmos5l_nor2_1
X_2549_ _2550_/B _2568_/A _2549_/B VPWR VGND sg13cmos5l_nor2_1
XFILLER_0_628 VPWR VGND sg13cmos5l_decap_8
XFILLER_29_846 VPWR VGND sg13cmos5l_decap_8
XFILLER_44_827 VPWR VGND sg13cmos5l_decap_8
XFILLER_28_389 VPWR VGND sg13cmos5l_fill_2
XFILLER_43_359 VPWR VGND sg13cmos5l_decap_8
XFILLER_24_584 VPWR VGND sg13cmos5l_decap_8
XFILLER_34_99 VPWR VGND sg13cmos5l_fill_1
XFILLER_8_739 VPWR VGND sg13cmos5l_decap_8
XFILLER_7_227 VPWR VGND sg13cmos5l_decap_8
XFILLER_11_278 VPWR VGND sg13cmos5l_decap_8
XFILLER_4_923 VPWR VGND sg13cmos5l_decap_8
XFILLER_3_411 VPWR VGND sg13cmos5l_fill_1
XFILLER_3_477 VPWR VGND sg13cmos5l_decap_8
XFILLER_3_455 VPWR VGND sg13cmos5l_fill_1
XFILLER_47_665 VPWR VGND sg13cmos5l_decap_4
XFILLER_19_334 VPWR VGND sg13cmos5l_decap_8
XFILLER_35_816 VPWR VGND sg13cmos5l_decap_4
XFILLER_19_367 VPWR VGND sg13cmos5l_decap_4
XFILLER_34_359 VPWR VGND sg13cmos5l_decap_4
XFILLER_43_871 VPWR VGND sg13cmos5l_decap_8
X_1920_ _1971_/B _2202_/C VPWR VGND sg13cmos5l_inv_1
XFILLER_15_595 VPWR VGND sg13cmos5l_decap_4
X_1851_ _2041_/B _1861_/A _1862_/B VPWR VGND sg13cmos5l_and2_1
XFILLER_30_598 VPWR VGND sg13cmos5l_decap_8
X_1782_ _1805_/B _2934_/A _2916_/A VPWR VGND sg13cmos5l_nor2_1
XFILLER_7_783 VPWR VGND sg13cmos5l_decap_8
X_2403_ _3106_/D _2404_/A _2403_/B VPWR VGND sg13cmos5l_xnor2_1
X_2334_ _2440_/B _3112_/Q _3111_/Q _3113_/Q VPWR VGND sg13cmos5l_nor3_1
X_2265_ _2268_/B _2266_/A _2021_/B _2139_/B _2076_/A VPWR VGND sg13cmos5l_a22oi_1
XFILLER_38_665 VPWR VGND sg13cmos5l_fill_2
X_2196_ _2197_/C _2196_/A _2196_/B _2196_/C _2196_/D VPWR VGND sg13cmos5l_nand4_1
XFILLER_26_805 VPWR VGND sg13cmos5l_decap_8
XFILLER_25_304 VPWR VGND sg13cmos5l_decap_4
XFILLER_37_197 VPWR VGND sg13cmos5l_decap_4
XFILLER_37_186 VPWR VGND sg13cmos5l_fill_1
XFILLER_34_882 VPWR VGND sg13cmos5l_decap_8
XFILLER_33_392 VPWR VGND sg13cmos5l_decap_8
XFILLER_14_1010 VPWR VGND sg13cmos5l_decap_8
XFILLER_21_587 VPWR VGND sg13cmos5l_decap_8
XFILLER_20_57 VPWR VGND sg13cmos5l_decap_8
XFILLER_1_926 VPWR VGND sg13cmos5l_decap_8
XFILLER_0_425 VPWR VGND sg13cmos5l_decap_8
XFILLER_29_11 VPWR VGND sg13cmos5l_decap_8
XFILLER_21_1025 VPWR VGND sg13cmos5l_decap_4
XFILLER_28_175 VPWR VGND sg13cmos5l_decap_8
XFILLER_45_76 VPWR VGND sg13cmos5l_decap_8
XFILLER_43_189 VPWR VGND sg13cmos5l_fill_2
XFILLER_24_370 VPWR VGND sg13cmos5l_decap_8
XFILLER_12_587 VPWR VGND sg13cmos5l_fill_1
XFILLER_6_48 VPWR VGND sg13cmos5l_decap_8
XFILLER_4_720 VPWR VGND sg13cmos5l_decap_8
XFILLER_4_797 VPWR VGND sg13cmos5l_decap_8
XFILLER_6_1019 VPWR VGND sg13cmos5l_decap_8
XFILLER_0_992 VPWR VGND sg13cmos5l_decap_8
XFILLER_48_963 VPWR VGND sg13cmos5l_decap_8
X_2050_ _2051_/D _2049_/Y _2212_/B _2050_/C VPWR VGND sg13cmos5l_nand3b_1
XFILLER_47_462 VPWR VGND sg13cmos5l_decap_8
XFILLER_35_657 VPWR VGND sg13cmos5l_fill_2
XFILLER_19_175 VPWR VGND sg13cmos5l_decap_8
XFILLER_34_112 VPWR VGND sg13cmos5l_decap_4
XFILLER_37_1010 VPWR VGND sg13cmos5l_decap_8
XFILLER_22_307 VPWR VGND sg13cmos5l_decap_8
X_2952_ _2953_/C _2952_/A _2952_/B _2952_/C _2952_/D VPWR VGND sg13cmos5l_nand4_1
X_1903_ _1903_/Y _1903_/A _1903_/B _1903_/C VPWR VGND sg13cmos5l_nor3_1
XFILLER_30_362 VPWR VGND sg13cmos5l_decap_8
X_2883_ _2883_/Y _2883_/A _2902_/B VPWR VGND sg13cmos5l_nand2_1
XFILLER_31_885 VPWR VGND sg13cmos5l_decap_8
X_1834_ _1834_/Y _2596_/C _1919_/B _2332_/C VPWR VGND sg13cmos5l_nand3_1
XFILLER_30_384 VPWR VGND sg13cmos5l_fill_2
X_1765_ _2358_/B _3027_/Q _3024_/Q _3025_/Q _3026_/Q _2392_/A _2353_/S VPWR VGND sg13cmos5l_mux4_1
X_1696_ _1698_/B _1696_/A _1696_/B _1696_/C VPWR VGND sg13cmos5l_nor3_1
X_2317_ _2318_/B _2317_/A _2317_/B VPWR VGND sg13cmos5l_nand2_1
X_2248_ _2249_/B _2245_/Y _2247_/Y _2231_/A VPWR VGND sg13cmos5l_o21ai_1
XFILLER_39_996 VPWR VGND sg13cmos5l_decap_8
XFILLER_38_484 VPWR VGND sg13cmos5l_decap_8
X_2179_ _2179_/Y _1989_/B _2178_/B _2178_/A VPWR VGND sg13cmos5l_a21oi_1
XFILLER_25_112 VPWR VGND sg13cmos5l_decap_8
XFILLER_26_635 VPWR VGND sg13cmos5l_fill_1
XFILLER_13_307 VPWR VGND sg13cmos5l_decap_8
XFILLER_41_649 VPWR VGND sg13cmos5l_decap_8
XFILLER_40_104 VPWR VGND sg13cmos5l_fill_2
XFILLER_25_178 VPWR VGND sg13cmos5l_fill_2
XFILLER_21_351 VPWR VGND sg13cmos5l_decap_8
XFILLER_21_395 VPWR VGND sg13cmos5l_decap_8
XFILLER_31_34 VPWR VGND sg13cmos5l_fill_2
XFILLER_5_517 VPWR VGND sg13cmos5l_decap_8
XFILLER_31_89 VPWR VGND sg13cmos5l_decap_8
XFILLER_0_200 VPWR VGND sg13cmos5l_decap_8
XFILLER_1_723 VPWR VGND sg13cmos5l_decap_8
XFILLER_49_716 VPWR VGND sg13cmos5l_decap_4
XFILLER_0_255 VPWR VGND sg13cmos5l_decap_8
XFILLER_49_727 VPWR VGND sg13cmos5l_decap_8
XFILLER_17_613 VPWR VGND sg13cmos5l_decap_8
XFILLER_45_933 VPWR VGND sg13cmos5l_decap_8
XFILLER_16_145 VPWR VGND sg13cmos5l_decap_8
XFILLER_32_616 VPWR VGND sg13cmos5l_decap_8
XFILLER_40_671 VPWR VGND sg13cmos5l_decap_8
XFILLER_8_333 VPWR VGND sg13cmos5l_fill_2
XFILLER_9_856 VPWR VGND sg13cmos5l_decap_8
XFILLER_12_373 VPWR VGND sg13cmos5l_decap_4
XFILLER_8_377 VPWR VGND sg13cmos5l_decap_8
X_1550_ _1550_/Y _2605_/B _3133_/Q VPWR VGND sg13cmos5l_nor2b_1
X_1481_ _1862_/A _1861_/A VPWR VGND sg13cmos5l_inv_1
XFILLER_39_204 VPWR VGND sg13cmos5l_decap_8
X_2102_ _2102_/Y _2270_/A _2290_/C _2309_/A VPWR VGND sg13cmos5l_nor3_1
XFILLER_36_922 VPWR VGND sg13cmos5l_decap_8
X_3082_ _3082_/Q _3103_/CLK _3082_/D fanout164/X VPWR VGND sg13cmos5l_dfrbpq_1
X_2033_ _2033_/Y _2148_/A _2029_/Y _2032_/Y VPWR VGND sg13cmos5l_a21oi_1
XFILLER_36_999 VPWR VGND sg13cmos5l_decap_8
XFILLER_22_137 VPWR VGND sg13cmos5l_decap_4
X_2935_ _2940_/B _2935_/A _2935_/B _2935_/C _2935_/D VPWR VGND sg13cmos5l_nand4_1
XFILLER_22_159 VPWR VGND sg13cmos5l_decap_8
XFILLER_31_660 VPWR VGND sg13cmos5l_decap_8
X_2866_ _2866_/Y _2886_/A1 _2865_/Y _2862_/Y VPWR VGND sg13cmos5l_o21ai_1
XFILLER_11_1013 VPWR VGND sg13cmos5l_decap_8
X_1817_ _3126_/D _1817_/A _1818_/B _2339_/B VPWR VGND sg13cmos5l_nor3_1
Xhold300 _2985_/D _2527_/X VPWR VGND sg13cmos5l_dlygate4sd3_1
X_2797_ _2801_/B _3035_/Q _3051_/Q VPWR VGND sg13cmos5l_xor2_1
Xhold311 _2483_/A _2977_/Q VPWR VGND sg13cmos5l_dlygate4sd3_1
Xhold322 _2821_/A _3052_/Q VPWR VGND sg13cmos5l_dlygate4sd3_1
Xhold333 _2833_/A _3056_/Q VPWR VGND sg13cmos5l_dlygate4sd3_1
XFILLER_2_509 VPWR VGND sg13cmos5l_decap_8
Xhold344 _2615_/B _2614_/X VPWR VGND sg13cmos5l_dlygate4sd3_1
X_1748_ _1749_/B _3134_/Q _1748_/B VPWR VGND sg13cmos5l_xnor2_1
Xhold355 _1508_/A _3033_/Q VPWR VGND sg13cmos5l_dlygate4sd3_1
Xhold366 hold366/X _3012_/Q VPWR VGND sg13cmos5l_dlygate4sd3_1
X_1679_ _1679_/Y _1739_/B _1739_/C VPWR VGND sg13cmos5l_nand2_1
Xhold377 _3068_/D _2873_/Y VPWR VGND sg13cmos5l_dlygate4sd3_1
Xhold399 _1710_/A _3128_/Q VPWR VGND sg13cmos5l_dlygate4sd3_1
Xhold388 _2857_/A _3064_/Q VPWR VGND sg13cmos5l_dlygate4sd3_1
XFILLER_45_207 VPWR VGND sg13cmos5l_fill_2
XFILLER_27_955 VPWR VGND sg13cmos5l_decap_8
XFILLER_14_605 VPWR VGND sg13cmos5l_decap_8
XFILLER_26_432 VPWR VGND sg13cmos5l_decap_8
XFILLER_41_424 VPWR VGND sg13cmos5l_decap_4
XFILLER_13_104 VPWR VGND sg13cmos5l_decap_8
XFILLER_14_638 VPWR VGND sg13cmos5l_fill_2
XFILLER_42_44 VPWR VGND sg13cmos5l_fill_1
XFILLER_42_55 VPWR VGND sg13cmos5l_decap_8
XFILLER_10_822 VPWR VGND sg13cmos5l_decap_8
XFILLER_10_833 VPWR VGND sg13cmos5l_fill_1
XFILLER_6_837 VPWR VGND sg13cmos5l_decap_8
XFILLER_10_888 VPWR VGND sg13cmos5l_decap_8
XFILLER_3_27 VPWR VGND sg13cmos5l_decap_4
XFILLER_17_410 VPWR VGND sg13cmos5l_decap_8
XFILLER_18_922 VPWR VGND sg13cmos5l_decap_8
XFILLER_33_914 VPWR VGND sg13cmos5l_decap_8
XFILLER_45_785 VPWR VGND sg13cmos5l_decap_8
XFILLER_18_999 VPWR VGND sg13cmos5l_decap_8
XFILLER_32_457 VPWR VGND sg13cmos5l_decap_8
XFILLER_41_980 VPWR VGND sg13cmos5l_decap_8
X_2720_ _2720_/X _2715_/Y _2718_/Y _2719_/Y VPWR VGND sg13cmos5l_a21o_1
XFILLER_8_130 VPWR VGND sg13cmos5l_decap_8
X_2651_ _2662_/A _2916_/A _2927_/A _3080_/Q VPWR VGND sg13cmos5l_nand3b_1
XFILLER_8_152 VPWR VGND sg13cmos5l_decap_8
X_1602_ _1609_/B _1718_/B _1696_/B _1602_/C _1602_/D VPWR VGND sg13cmos5l_nor4_1
X_2582_ _2582_/X _3011_/Q _2494_/A _2582_/S VPWR VGND sg13cmos5l_mux2_1
XFILLER_5_881 VPWR VGND sg13cmos5l_decap_8
X_1533_ _1535_/A _2362_/A _2369_/A VPWR VGND sg13cmos5l_nand2b_1
Xfanout109 _2224_/C _3106_/Q VPWR VGND sg13cmos5l_buf_1
X_3134_ _3134_/Q _3134_/CLK _3134_/D fanout168/X VPWR VGND sg13cmos5l_dfrbpq_1
X_3065_ _3065_/Q _3093_/CLK _3065_/D fanout169/X VPWR VGND sg13cmos5l_dfrbpq_1
X_2016_ _2016_/Y _2263_/A _2015_/X _2199_/A VPWR VGND sg13cmos5l_a21oi_1
XFILLER_36_796 VPWR VGND sg13cmos5l_decap_8
XFILLER_35_251 VPWR VGND sg13cmos5l_fill_1
XFILLER_24_958 VPWR VGND sg13cmos5l_decap_8
X_2918_ _2918_/X _2927_/A _2943_/B _3032_/Q VPWR VGND sg13cmos5l_a21o_1
XFILLER_10_129 VPWR VGND sg13cmos5l_decap_8
X_2849_ _2849_/Y _2849_/A _2848_/Y VPWR VGND sg13cmos5l_nor2b_1
Xhold196 _3102_/D _3101_/Q VPWR VGND sg13cmos5l_dlygate4sd3_1
XFILLER_46_505 VPWR VGND sg13cmos5l_decap_8
XFILLER_46_527 VPWR VGND sg13cmos5l_decap_8
XFILLER_26_240 VPWR VGND sg13cmos5l_decap_8
XFILLER_42_711 VPWR VGND sg13cmos5l_fill_1
XFILLER_15_914 VPWR VGND sg13cmos5l_decap_8
XFILLER_26_273 VPWR VGND sg13cmos5l_decap_8
XFILLER_27_796 VPWR VGND sg13cmos5l_decap_8
XFILLER_42_744 VPWR VGND sg13cmos5l_decap_8
XFILLER_42_733 VPWR VGND sg13cmos5l_fill_2
XFILLER_26_284 VPWR VGND sg13cmos5l_fill_2
XFILLER_42_788 VPWR VGND sg13cmos5l_fill_1
XFILLER_14_479 VPWR VGND sg13cmos5l_decap_8
XFILLER_30_939 VPWR VGND sg13cmos5l_decap_8
XFILLER_41_287 VPWR VGND sg13cmos5l_decap_8
XFILLER_10_674 VPWR VGND sg13cmos5l_decap_4
XFILLER_2_873 VPWR VGND sg13cmos5l_decap_8
XFILLER_49_310 VPWR VGND sg13cmos5l_decap_8
XFILLER_37_538 VPWR VGND sg13cmos5l_decap_8
XFILLER_37_527 VPWR VGND sg13cmos5l_decap_8
XFILLER_18_796 VPWR VGND sg13cmos5l_decap_8
XFILLER_17_284 VPWR VGND sg13cmos5l_fill_1
XFILLER_32_232 VPWR VGND sg13cmos5l_decap_8
XFILLER_33_733 VPWR VGND sg13cmos5l_fill_2
XFILLER_21_906 VPWR VGND sg13cmos5l_decap_8
XFILLER_33_788 VPWR VGND sg13cmos5l_decap_8
XFILLER_20_427 VPWR VGND sg13cmos5l_fill_1
XFILLER_32_287 VPWR VGND sg13cmos5l_decap_8
X_2703_ _2704_/A hold434/X _2648_/A _2701_/Y _2702_/Y VPWR VGND sg13cmos5l_a22oi_1
X_2634_ _3028_/D _2632_/Y _2637_/S _2634_/S VPWR VGND sg13cmos5l_mux2_1
X_2565_ _2567_/B _2565_/A _2565_/B VPWR VGND sg13cmos5l_xnor2_1
X_1516_ _2511_/A _2995_/Q VPWR VGND sg13cmos5l_inv_1
X_2496_ _2499_/D _2509_/A _2496_/B VPWR VGND sg13cmos5l_nor2_1
X_3117_ _3117_/Q _3117_/CLK _3117_/D fanout150/X VPWR VGND sg13cmos5l_dfrbpq_1
XFILLER_43_519 VPWR VGND sg13cmos5l_decap_8
X_3048_ _3048_/Q _3057_/CLK _3048_/D fanout172/X VPWR VGND sg13cmos5l_dfrbpq_1
XFILLER_11_405 VPWR VGND sg13cmos5l_decap_4
XFILLER_23_79 VPWR VGND sg13cmos5l_decap_8
XFILLER_20_994 VPWR VGND sg13cmos5l_decap_8
XFILLER_3_626 VPWR VGND sg13cmos5l_decap_8
XFILLER_2_136 VPWR VGND sg13cmos5l_decap_8
XFILLER_47_814 VPWR VGND sg13cmos5l_decap_8
XFILLER_19_505 VPWR VGND sg13cmos5l_fill_2
XFILLER_47_825 VPWR VGND sg13cmos5l_fill_2
XFILLER_48_87 VPWR VGND sg13cmos5l_decap_8
XFILLER_0_39 VPWR VGND sg13cmos5l_decap_8
XFILLER_0_28 VPWR VGND sg13cmos5l_decap_8
XFILLER_19_549 VPWR VGND sg13cmos5l_decap_8
XFILLER_34_508 VPWR VGND sg13cmos5l_fill_1
XFILLER_46_368 VPWR VGND sg13cmos5l_decap_4
XFILLER_42_530 VPWR VGND sg13cmos5l_fill_1
XFILLER_15_755 VPWR VGND sg13cmos5l_decap_8
XFILLER_14_254 VPWR VGND sg13cmos5l_decap_8
XFILLER_42_585 VPWR VGND sg13cmos5l_decap_8
XFILLER_14_287 VPWR VGND sg13cmos5l_decap_8
Xfanout80 _2749_/B _2717_/B VPWR VGND sg13cmos5l_buf_1
XFILLER_11_950 VPWR VGND sg13cmos5l_decap_8
Xfanout91 _1972_/C _1776_/Y VPWR VGND sg13cmos5l_buf_1
XFILLER_7_965 VPWR VGND sg13cmos5l_decap_8
XFILLER_13_90 VPWR VGND sg13cmos5l_decap_8
XFILLER_6_486 VPWR VGND sg13cmos5l_decap_8
XFILLER_9_1017 VPWR VGND sg13cmos5l_decap_8
XFILLER_9_1028 VPWR VGND sg13cmos5l_fill_1
X_2350_ _2350_/Y _2350_/A _2358_/C _2350_/C VPWR VGND sg13cmos5l_nor3_1
X_2281_ _2401_/B _2281_/A _2285_/B VPWR VGND sg13cmos5l_nand2_1
XFILLER_2_670 VPWR VGND sg13cmos5l_decap_8
XFILLER_29_4 VPWR VGND sg13cmos5l_decap_8
XFILLER_37_302 VPWR VGND sg13cmos5l_fill_1
XFILLER_38_858 VPWR VGND sg13cmos5l_decap_4
XFILLER_21_725 VPWR VGND sg13cmos5l_decap_8
X_1996_ _2229_/A _2259_/B _2151_/B VPWR VGND sg13cmos5l_nand2_1
XFILLER_21_769 VPWR VGND sg13cmos5l_fill_1
XFILLER_20_279 VPWR VGND sg13cmos5l_decap_4
X_2617_ _2617_/Y _2617_/A _2617_/B VPWR VGND sg13cmos5l_nor2_1
X_2548_ _2549_/B _2991_/Q _2990_/Q VPWR VGND sg13cmos5l_nand2_1
XFILLER_0_607 VPWR VGND sg13cmos5l_decap_8
X_2479_ _2479_/Y _2978_/Q _2485_/A2 _2635_/A _2473_/Y VPWR VGND sg13cmos5l_a22oi_1
XFILLER_18_13 VPWR VGND sg13cmos5l_decap_8
XFILLER_29_825 VPWR VGND sg13cmos5l_decap_8
XFILLER_16_519 VPWR VGND sg13cmos5l_decap_8
XFILLER_37_891 VPWR VGND sg13cmos5l_fill_1
XFILLER_24_563 VPWR VGND sg13cmos5l_decap_8
XFILLER_11_202 VPWR VGND sg13cmos5l_fill_1
XFILLER_12_714 VPWR VGND sg13cmos5l_decap_8
XFILLER_34_67 VPWR VGND sg13cmos5l_decap_8
XFILLER_8_718 VPWR VGND sg13cmos5l_decap_8
XFILLER_11_257 VPWR VGND sg13cmos5l_decap_8
XFILLER_12_758 VPWR VGND sg13cmos5l_fill_1
XFILLER_7_206 VPWR VGND sg13cmos5l_decap_8
Xclkload0 clkload0/Y clkload0/A VPWR VGND sg13cmos5l_inv_1
XFILLER_4_902 VPWR VGND sg13cmos5l_decap_8
Xclkbuf_5_29__f_clk clkload7/A clkbuf_4_14_0_clk/X VPWR VGND sg13cmos5l_buf_8
XFILLER_4_979 VPWR VGND sg13cmos5l_decap_8
XFILLER_47_600 VPWR VGND sg13cmos5l_decap_4
XFILLER_47_644 VPWR VGND sg13cmos5l_decap_8
XFILLER_46_132 VPWR VGND sg13cmos5l_fill_1
XFILLER_46_110 VPWR VGND sg13cmos5l_decap_8
XFILLER_46_154 VPWR VGND sg13cmos5l_fill_1
XFILLER_27_390 VPWR VGND sg13cmos5l_decap_8
XFILLER_15_574 VPWR VGND sg13cmos5l_decap_8
X_1850_ _1989_/B _2244_/A _2244_/C VPWR VGND sg13cmos5l_nand2_1
X_1781_ _2916_/A _2442_/B _2442_/C VPWR VGND sg13cmos5l_nor2_1
XFILLER_7_762 VPWR VGND sg13cmos5l_decap_8
XFILLER_6_283 VPWR VGND sg13cmos5l_decap_8
X_2402_ _3104_/D _2402_/A _2594_/B VPWR VGND sg13cmos5l_nor2_1
X_2333_ _2335_/C _3110_/Q _3112_/Q _3113_/Q VPWR VGND sg13cmos5l_nor3_1
XFILLER_38_622 VPWR VGND sg13cmos5l_fill_2
X_2264_ _2269_/B _2270_/B _2165_/X _2258_/Y VPWR VGND sg13cmos5l_a21oi_1
XFILLER_38_655 VPWR VGND sg13cmos5l_fill_1
XFILLER_38_644 VPWR VGND sg13cmos5l_decap_8
X_2195_ _2196_/D _2057_/B _2029_/B _2037_/A VPWR VGND sg13cmos5l_o21ai_1
XFILLER_37_165 VPWR VGND sg13cmos5l_fill_2
XFILLER_37_176 VPWR VGND sg13cmos5l_decap_4
XFILLER_33_371 VPWR VGND sg13cmos5l_decap_8
XFILLER_21_566 VPWR VGND sg13cmos5l_decap_8
X_1979_ _1979_/Y _2268_/A _1979_/B _1979_/C VPWR VGND sg13cmos5l_nand3_1
XFILLER_20_25 VPWR VGND sg13cmos5l_decap_8
XFILLER_0_404 VPWR VGND sg13cmos5l_decap_8
XFILLER_1_905 VPWR VGND sg13cmos5l_decap_8
XFILLER_49_909 VPWR VGND sg13cmos5l_decap_8
XFILLER_29_34 VPWR VGND sg13cmos5l_fill_1
XFILLER_29_56 VPWR VGND sg13cmos5l_fill_2
XFILLER_21_1004 VPWR VGND sg13cmos5l_decap_8
XFILLER_28_121 VPWR VGND sg13cmos5l_fill_1
XFILLER_29_655 VPWR VGND sg13cmos5l_decap_8
XFILLER_17_839 VPWR VGND sg13cmos5l_decap_4
XFILLER_28_154 VPWR VGND sg13cmos5l_decap_8
XFILLER_45_44 VPWR VGND sg13cmos5l_decap_8
XFILLER_44_636 VPWR VGND sg13cmos5l_fill_2
XFILLER_44_625 VPWR VGND sg13cmos5l_decap_8
XFILLER_43_124 VPWR VGND sg13cmos5l_decap_8
XFILLER_43_113 VPWR VGND sg13cmos5l_fill_2
XFILLER_16_327 VPWR VGND sg13cmos5l_decap_8
XFILLER_28_198 VPWR VGND sg13cmos5l_fill_1
XFILLER_45_66 VPWR VGND sg13cmos5l_fill_1
XFILLER_43_168 VPWR VGND sg13cmos5l_decap_8
XFILLER_25_872 VPWR VGND sg13cmos5l_decap_8
XFILLER_6_27 VPWR VGND sg13cmos5l_decap_8
XFILLER_4_776 VPWR VGND sg13cmos5l_decap_8
XFILLER_3_264 VPWR VGND sg13cmos5l_fill_2
XFILLER_0_971 VPWR VGND sg13cmos5l_decap_8
XFILLER_48_942 VPWR VGND sg13cmos5l_decap_8
XFILLER_19_110 VPWR VGND sg13cmos5l_decap_8
XFILLER_19_132 VPWR VGND sg13cmos5l_fill_1
XFILLER_35_636 VPWR VGND sg13cmos5l_decap_8
X_2951_ _2953_/B _3035_/Q _2951_/B VPWR VGND sg13cmos5l_xor2_1
XFILLER_34_179 VPWR VGND sg13cmos5l_decap_8
XFILLER_43_691 VPWR VGND sg13cmos5l_decap_8
X_1902_ _1903_/C _1897_/Y _1901_/Y _1896_/Y VPWR VGND sg13cmos5l_a21oi_1
XFILLER_15_382 VPWR VGND sg13cmos5l_decap_4
XFILLER_31_853 VPWR VGND sg13cmos5l_decap_8
X_2882_ _2882_/Y _2886_/A1 _2881_/X _2879_/Y VPWR VGND sg13cmos5l_o21ai_1
X_1833_ _1844_/B _2596_/C _1919_/B _2332_/C VPWR VGND sg13cmos5l_and3_1
XFILLER_30_396 VPWR VGND sg13cmos5l_decap_8
X_1764_ _1771_/B _1763_/Y _1764_/B VPWR VGND sg13cmos5l_nand2b_1
X_1695_ _1695_/Y _1726_/A _1679_/Y _1694_/Y VPWR VGND sg13cmos5l_a21oi_1
Xclkbuf_5_12__f_clk _3103_/CLK clkbuf_4_6_0_clk/X VPWR VGND sg13cmos5l_buf_8
X_2316_ _2322_/D _2316_/A _1872_/Y VPWR VGND sg13cmos5l_nor2b_1
X_2247_ _2247_/Y _1856_/Y _2063_/A _2178_/B _2246_/Y _2317_/A VPWR VGND sg13cmos5l_a221oi_1
XFILLER_39_975 VPWR VGND sg13cmos5l_decap_8
XFILLER_38_441 VPWR VGND sg13cmos5l_decap_4
X_2178_ _2178_/X _2178_/A _2178_/B VPWR VGND sg13cmos5l_or2_1
XFILLER_41_606 VPWR VGND sg13cmos5l_fill_2
XFILLER_25_157 VPWR VGND sg13cmos5l_decap_8
XFILLER_41_617 VPWR VGND sg13cmos5l_decap_8
XFILLER_40_116 VPWR VGND sg13cmos5l_fill_2
XFILLER_40_149 VPWR VGND sg13cmos5l_decap_8
XFILLER_21_330 VPWR VGND sg13cmos5l_decap_8
XFILLER_22_875 VPWR VGND sg13cmos5l_decap_8
XFILLER_31_46 VPWR VGND sg13cmos5l_decap_8
XFILLER_31_79 VPWR VGND sg13cmos5l_decap_4
XFILLER_1_702 VPWR VGND sg13cmos5l_decap_8
XFILLER_1_779 VPWR VGND sg13cmos5l_decap_8
XFILLER_45_912 VPWR VGND sg13cmos5l_decap_8
XFILLER_45_989 VPWR VGND sg13cmos5l_decap_8
XFILLER_17_669 VPWR VGND sg13cmos5l_decap_8
XFILLER_44_477 VPWR VGND sg13cmos5l_fill_2
XFILLER_25_680 VPWR VGND sg13cmos5l_decap_8
XFILLER_31_116 VPWR VGND sg13cmos5l_decap_8
XFILLER_9_835 VPWR VGND sg13cmos5l_decap_8
XFILLER_12_352 VPWR VGND sg13cmos5l_decap_8
XFILLER_13_864 VPWR VGND sg13cmos5l_decap_8
XFILLER_13_897 VPWR VGND sg13cmos5l_decap_8
XFILLER_4_584 VPWR VGND sg13cmos5l_fill_2
X_1480_ _1480_/Y _2246_/A VPWR VGND sg13cmos5l_inv_1
X_2101_ _2309_/A _2101_/A _2202_/B _2259_/A VPWR VGND sg13cmos5l_nor3_1
X_3081_ _3081_/Q clkload6/A _3081_/D fanout164/X VPWR VGND sg13cmos5l_dfrbpq_1
XFILLER_36_901 VPWR VGND sg13cmos5l_decap_8
X_2032_ _2032_/Y _2032_/A _2074_/A _2032_/C VPWR VGND sg13cmos5l_nand3_1
XFILLER_11_4 VPWR VGND sg13cmos5l_decap_4
XFILLER_36_978 VPWR VGND sg13cmos5l_decap_8
XFILLER_35_433 VPWR VGND sg13cmos5l_decap_8
XFILLER_23_606 VPWR VGND sg13cmos5l_decap_8
XFILLER_22_116 VPWR VGND sg13cmos5l_decap_8
X_2934_ _2935_/D _2934_/A _3041_/Q _2934_/C VPWR VGND sg13cmos5l_or3_1
XFILLER_15_190 VPWR VGND sg13cmos5l_decap_8
X_2865_ _2865_/Y _2869_/B _2865_/B VPWR VGND sg13cmos5l_nand2_1
X_1816_ _3125_/D _1816_/A _2339_/B VPWR VGND sg13cmos5l_nor2_1
X_2796_ _2803_/C _3041_/Q _2836_/A VPWR VGND sg13cmos5l_xnor2_1
Xhold301 _2488_/A _2979_/Q VPWR VGND sg13cmos5l_dlygate4sd3_1
Xhold323 _2822_/B _2820_/Y VPWR VGND sg13cmos5l_dlygate4sd3_1
Xhold334 _2834_/B _2832_/Y VPWR VGND sg13cmos5l_dlygate4sd3_1
X_1747_ _1752_/B _3134_/Q _1748_/B VPWR VGND sg13cmos5l_nor2b_1
Xhold312 hold312/X _2483_/Y VPWR VGND sg13cmos5l_dlygate4sd3_1
Xhold378 _2509_/A _3000_/Q VPWR VGND sg13cmos5l_dlygate4sd3_1
Xhold367 _3011_/D _2591_/X VPWR VGND sg13cmos5l_dlygate4sd3_1
X_1678_ _1739_/C _1633_/B _1644_/C _1677_/Y VPWR VGND sg13cmos5l_a21o_1
Xhold356 _2390_/A _3120_/Q VPWR VGND sg13cmos5l_dlygate4sd3_1
Xhold345 _2895_/B _3074_/Q VPWR VGND sg13cmos5l_dlygate4sd3_1
Xhold389 _2574_/A _3005_/Q VPWR VGND sg13cmos5l_dlygate4sd3_1
XFILLER_45_219 VPWR VGND sg13cmos5l_decap_8
XFILLER_38_271 VPWR VGND sg13cmos5l_decap_8
XFILLER_26_411 VPWR VGND sg13cmos5l_decap_8
XFILLER_27_934 VPWR VGND sg13cmos5l_decap_8
XFILLER_26_46 VPWR VGND sg13cmos5l_fill_2
XFILLER_26_57 VPWR VGND sg13cmos5l_decap_8
XFILLER_26_455 VPWR VGND sg13cmos5l_decap_8
XFILLER_41_403 VPWR VGND sg13cmos5l_decap_8
XFILLER_42_959 VPWR VGND sg13cmos5l_decap_8
XFILLER_9_109 VPWR VGND sg13cmos5l_decap_8
XFILLER_10_845 VPWR VGND sg13cmos5l_decap_8
XFILLER_21_171 VPWR VGND sg13cmos5l_decap_4
XFILLER_6_816 VPWR VGND sg13cmos5l_decap_8
XFILLER_10_867 VPWR VGND sg13cmos5l_decap_8
XFILLER_37_709 VPWR VGND sg13cmos5l_decap_8
XFILLER_18_901 VPWR VGND sg13cmos5l_decap_8
XFILLER_17_433 VPWR VGND sg13cmos5l_fill_1
XFILLER_17_455 VPWR VGND sg13cmos5l_decap_8
XFILLER_18_978 VPWR VGND sg13cmos5l_decap_8
XFILLER_17_488 VPWR VGND sg13cmos5l_decap_8
XFILLER_32_436 VPWR VGND sg13cmos5l_decap_8
XFILLER_9_610 VPWR VGND sg13cmos5l_decap_4
XFILLER_13_672 VPWR VGND sg13cmos5l_decap_8
X_2650_ _3030_/D _2640_/Y _2646_/Y _2649_/Y VPWR VGND sg13cmos5l_a21oi_1
XFILLER_9_654 VPWR VGND sg13cmos5l_decap_8
XFILLER_12_182 VPWR VGND sg13cmos5l_fill_1
XFILLER_8_175 VPWR VGND sg13cmos5l_decap_8
X_1601_ _1602_/D _1604_/A _1660_/A _1726_/A VPWR VGND sg13cmos5l_o21ai_1
X_2581_ _2581_/X _3010_/Q _2494_/B _2582_/S VPWR VGND sg13cmos5l_mux2_1
XFILLER_5_860 VPWR VGND sg13cmos5l_decap_8
X_1532_ _2369_/A _2972_/Q _2969_/Q _2970_/Q _2971_/Q _1527_/A hold464/X VPWR VGND
+ sg13cmos5l_mux4_1
X_3133_ _3133_/Q _3134_/CLK _3133_/D fanout167/X VPWR VGND sg13cmos5l_dfrbpq_1
X_3064_ _3064_/Q _3136_/CLK _3064_/D fanout169/X VPWR VGND sg13cmos5l_dfrbpq_1
X_2015_ _2015_/X _2009_/Y _2010_/Y _2014_/Y VPWR VGND sg13cmos5l_a21o_1
XFILLER_36_775 VPWR VGND sg13cmos5l_decap_8
XFILLER_23_414 VPWR VGND sg13cmos5l_decap_8
XFILLER_24_937 VPWR VGND sg13cmos5l_decap_8
X_2917_ _2917_/Y _3032_/Q _2927_/A _2943_/B VPWR VGND sg13cmos5l_nand3_1
X_2848_ _2848_/Y _2847_/A _2847_/B _2822_/A VPWR VGND sg13cmos5l_a21oi_1
XFILLER_12_48 VPWR VGND sg13cmos5l_decap_8
X_2779_ _2779_/X _2779_/A _2779_/B VPWR VGND sg13cmos5l_and2_1
XFILLER_3_819 VPWR VGND sg13cmos5l_decap_8
Xhold197 _3101_/D _3100_/Q VPWR VGND sg13cmos5l_dlygate4sd3_1
XFILLER_37_23 VPWR VGND sg13cmos5l_decap_4
XFILLER_39_580 VPWR VGND sg13cmos5l_decap_8
XFILLER_39_591 VPWR VGND sg13cmos5l_fill_2
XFILLER_42_701 VPWR VGND sg13cmos5l_fill_2
XFILLER_41_266 VPWR VGND sg13cmos5l_decap_8
XFILLER_14_458 VPWR VGND sg13cmos5l_fill_2
XFILLER_30_918 VPWR VGND sg13cmos5l_decap_8
XFILLER_22_480 VPWR VGND sg13cmos5l_fill_1
XFILLER_23_981 VPWR VGND sg13cmos5l_decap_8
XFILLER_6_602 VPWR VGND sg13cmos5l_decap_8
XFILLER_10_653 VPWR VGND sg13cmos5l_decap_8
XFILLER_22_491 VPWR VGND sg13cmos5l_decap_8
XFILLER_6_613 VPWR VGND sg13cmos5l_fill_1
XFILLER_5_189 VPWR VGND sg13cmos5l_fill_1
XFILLER_5_178 VPWR VGND sg13cmos5l_fill_2
XFILLER_2_852 VPWR VGND sg13cmos5l_decap_8
XFILLER_1_340 VPWR VGND sg13cmos5l_decap_4
XFILLER_1_373 VPWR VGND sg13cmos5l_fill_1
XFILLER_1_384 VPWR VGND sg13cmos5l_fill_1
XFILLER_49_366 VPWR VGND sg13cmos5l_decap_4
XFILLER_37_506 VPWR VGND sg13cmos5l_decap_8
XFILLER_49_399 VPWR VGND sg13cmos5l_decap_8
XFILLER_17_252 VPWR VGND sg13cmos5l_decap_8
XFILLER_18_775 VPWR VGND sg13cmos5l_decap_8
XFILLER_17_296 VPWR VGND sg13cmos5l_decap_4
XFILLER_32_266 VPWR VGND sg13cmos5l_decap_8
XFILLER_20_417 VPWR VGND sg13cmos5l_fill_1
X_2702_ _2702_/Y _2730_/A1 _1522_/Y _2730_/B1 VPWR VGND sg13cmos5l_a21oi_1
XFILLER_9_495 VPWR VGND sg13cmos5l_decap_8
X_2633_ _2637_/S _2672_/A _2465_/B _2632_/Y VPWR VGND sg13cmos5l_o21ai_1
X_2564_ _2565_/B _2564_/A _2564_/B VPWR VGND sg13cmos5l_xnor2_1
X_1515_ _2967_/A _3103_/D VPWR VGND sg13cmos5l_inv_1
X_2495_ _2496_/B _2509_/B _2509_/C VPWR VGND sg13cmos5l_nand2_1
XFILLER_4_82 VPWR VGND sg13cmos5l_fill_1
X_3116_ _3116_/Q _3119_/CLK _3116_/D fanout149/X VPWR VGND sg13cmos5l_dfrbpq_1
XFILLER_28_517 VPWR VGND sg13cmos5l_decap_4
XFILLER_28_539 VPWR VGND sg13cmos5l_fill_1
X_3047_ _3047_/Q _3057_/CLK _3047_/D fanout172/X VPWR VGND sg13cmos5l_dfrbpq_1
XFILLER_36_583 VPWR VGND sg13cmos5l_decap_8
XFILLER_23_222 VPWR VGND sg13cmos5l_decap_8
XFILLER_24_745 VPWR VGND sg13cmos5l_decap_8
XFILLER_11_428 VPWR VGND sg13cmos5l_decap_8
XFILLER_11_439 VPWR VGND sg13cmos5l_fill_2
XFILLER_23_299 VPWR VGND sg13cmos5l_decap_8
XFILLER_20_973 VPWR VGND sg13cmos5l_decap_8
XFILLER_3_605 VPWR VGND sg13cmos5l_decap_8
XFILLER_48_77 VPWR VGND sg13cmos5l_fill_1
XFILLER_46_358 VPWR VGND sg13cmos5l_decap_4
XFILLER_14_200 VPWR VGND sg13cmos5l_decap_4
XFILLER_14_233 VPWR VGND sg13cmos5l_decap_8
Xfanout92 _2746_/A _1500_/Y VPWR VGND sg13cmos5l_buf_1
Xfanout81 _2717_/B _2778_/B VPWR VGND sg13cmos5l_buf_1
Xfanout70 _2251_/A _1838_/Y VPWR VGND sg13cmos5l_buf_1
XFILLER_7_944 VPWR VGND sg13cmos5l_decap_8
XFILLER_6_410 VPWR VGND sg13cmos5l_decap_4
XFILLER_6_421 VPWR VGND sg13cmos5l_decap_8
XFILLER_43_7 VPWR VGND sg13cmos5l_fill_2
X_2280_ _2282_/B _2280_/A _2280_/B _2280_/C _2280_/D VPWR VGND sg13cmos5l_nor4_1
XFILLER_37_358 VPWR VGND sg13cmos5l_decap_8
XFILLER_18_594 VPWR VGND sg13cmos5l_decap_8
XFILLER_45_391 VPWR VGND sg13cmos5l_decap_8
XFILLER_33_564 VPWR VGND sg13cmos5l_decap_8
X_1995_ _2263_/A _2153_/A _2300_/A VPWR VGND sg13cmos5l_nor2_1
XFILLER_20_258 VPWR VGND sg13cmos5l_decap_8
XFILLER_9_281 VPWR VGND sg13cmos5l_decap_8
X_2616_ _2628_/B _2619_/B _2672_/A VPWR VGND sg13cmos5l_nor2b_1
X_2547_ _2991_/D _2547_/A VPWR VGND sg13cmos5l_inv_1
X_2478_ _2478_/Y _2480_/B _2476_/Y _2477_/Y VPWR VGND sg13cmos5l_a21oi_1
XFILLER_29_804 VPWR VGND sg13cmos5l_decap_8
XFILLER_28_347 VPWR VGND sg13cmos5l_fill_2
XFILLER_18_69 VPWR VGND sg13cmos5l_decap_8
XFILLER_43_339 VPWR VGND sg13cmos5l_fill_1
XFILLER_24_520 VPWR VGND sg13cmos5l_decap_4
XFILLER_24_542 VPWR VGND sg13cmos5l_decap_8
XFILLER_11_236 VPWR VGND sg13cmos5l_decap_4
Xclkload1 clkload1/Y clkload1/A VPWR VGND sg13cmos5l_inv_1
XFILLER_4_958 VPWR VGND sg13cmos5l_decap_8
XFILLER_3_446 VPWR VGND sg13cmos5l_decap_8
XFILLER_47_623 VPWR VGND sg13cmos5l_decap_4
XFILLER_19_303 VPWR VGND sg13cmos5l_decap_8
XFILLER_19_314 VPWR VGND sg13cmos5l_fill_1
XFILLER_46_166 VPWR VGND sg13cmos5l_decap_8
XFILLER_35_829 VPWR VGND sg13cmos5l_decap_8
XFILLER_28_881 VPWR VGND sg13cmos5l_decap_8
XFILLER_15_553 VPWR VGND sg13cmos5l_decap_8
XFILLER_42_372 VPWR VGND sg13cmos5l_decap_8
XFILLER_42_383 VPWR VGND sg13cmos5l_fill_1
XFILLER_30_556 VPWR VGND sg13cmos5l_decap_8
X_1780_ _1810_/A _3068_/Q _1780_/B VPWR VGND sg13cmos5l_xnor2_1
XFILLER_7_741 VPWR VGND sg13cmos5l_decap_8
XFILLER_11_781 VPWR VGND sg13cmos5l_decap_4
XFILLER_11_792 VPWR VGND sg13cmos5l_decap_8
X_2401_ _2599_/B _2412_/C _2401_/B _2401_/C _2401_/D VPWR VGND sg13cmos5l_or4_1
XFILLER_3_980 VPWR VGND sg13cmos5l_decap_8
X_2332_ _2336_/B _2332_/A _2332_/B _2332_/C VPWR VGND sg13cmos5l_nand3_1
X_2263_ _2263_/Y _2263_/A _2263_/B VPWR VGND sg13cmos5l_nand2_1
XFILLER_37_100 VPWR VGND sg13cmos5l_decap_8
X_2194_ _2197_/B _2194_/A _2194_/B _2194_/C VPWR VGND sg13cmos5l_nand3_1
XFILLER_37_155 VPWR VGND sg13cmos5l_fill_1
XFILLER_19_881 VPWR VGND sg13cmos5l_decap_8
XFILLER_25_328 VPWR VGND sg13cmos5l_decap_8
XFILLER_40_309 VPWR VGND sg13cmos5l_decap_8
XFILLER_33_350 VPWR VGND sg13cmos5l_decap_8
XFILLER_21_545 VPWR VGND sg13cmos5l_decap_8
X_1978_ _1979_/C _2148_/B _2251_/B _1977_/Y VPWR VGND sg13cmos5l_o21ai_1
XFILLER_16_306 VPWR VGND sg13cmos5l_fill_2
XFILLER_17_829 VPWR VGND sg13cmos5l_decap_4
XFILLER_40_854 VPWR VGND sg13cmos5l_decap_8
XFILLER_12_523 VPWR VGND sg13cmos5l_decap_8
XFILLER_40_898 VPWR VGND sg13cmos5l_decap_8
XFILLER_8_549 VPWR VGND sg13cmos5l_decap_8
XFILLER_4_755 VPWR VGND sg13cmos5l_decap_8
XFILLER_3_243 VPWR VGND sg13cmos5l_decap_8
XFILLER_3_276 VPWR VGND sg13cmos5l_decap_8
XFILLER_0_950 VPWR VGND sg13cmos5l_decap_8
XFILLER_10_92 VPWR VGND sg13cmos5l_fill_1
XFILLER_48_921 VPWR VGND sg13cmos5l_decap_8
XFILLER_48_998 VPWR VGND sg13cmos5l_decap_8
XFILLER_47_497 VPWR VGND sg13cmos5l_decap_4
XFILLER_35_615 VPWR VGND sg13cmos5l_decap_8
XFILLER_34_125 VPWR VGND sg13cmos5l_decap_8
XFILLER_34_158 VPWR VGND sg13cmos5l_decap_8
XFILLER_43_670 VPWR VGND sg13cmos5l_decap_8
X_2950_ _2952_/D _3036_/Q _2950_/B VPWR VGND sg13cmos5l_xnor2_1
XFILLER_15_361 VPWR VGND sg13cmos5l_decap_8
XFILLER_16_895 VPWR VGND sg13cmos5l_decap_8
X_1901_ _1901_/Y _2138_/A _1901_/B VPWR VGND sg13cmos5l_nand2_1
X_2881_ _2881_/X _2881_/A _2881_/B VPWR VGND sg13cmos5l_xor2_1
X_1832_ _1836_/B _1919_/B _2332_/C _2596_/C VPWR VGND sg13cmos5l_a21o_1
XFILLER_30_386 VPWR VGND sg13cmos5l_fill_1
X_1763_ _1763_/Y _3021_/Q _1759_/Y _1762_/X VPWR VGND sg13cmos5l_o21ai_1
X_1694_ _1694_/Y _1738_/B _1738_/C _1726_/A VPWR VGND sg13cmos5l_a21oi_1
XFILLER_44_1027 VPWR VGND sg13cmos5l_fill_2
XFILLER_44_1016 VPWR VGND sg13cmos5l_decap_8
XFILLER_32_0 VPWR VGND sg13cmos5l_decap_8
X_2315_ _2316_/A _2148_/A _2038_/B _2314_/Y VPWR VGND sg13cmos5l_a21oi_1
XFILLER_39_954 VPWR VGND sg13cmos5l_decap_8
X_2246_ _2246_/Y _2246_/A _2246_/B _2246_/C VPWR VGND sg13cmos5l_nand3_1
XFILLER_26_604 VPWR VGND sg13cmos5l_decap_8
X_2177_ _2199_/B _2273_/A _2177_/B _2177_/C VPWR VGND sg13cmos5l_nand3_1
XFILLER_25_103 VPWR VGND sg13cmos5l_decap_4
XFILLER_26_615 VPWR VGND sg13cmos5l_fill_2
XFILLER_26_659 VPWR VGND sg13cmos5l_decap_8
XFILLER_40_128 VPWR VGND sg13cmos5l_decap_8
XFILLER_15_59 VPWR VGND sg13cmos5l_decap_8
XFILLER_22_832 VPWR VGND sg13cmos5l_decap_8
XFILLER_21_386 VPWR VGND sg13cmos5l_decap_4
XFILLER_31_36 VPWR VGND sg13cmos5l_fill_1
XFILLER_0_235 VPWR VGND sg13cmos5l_decap_8
XFILLER_1_758 VPWR VGND sg13cmos5l_decap_8
XFILLER_5_1021 VPWR VGND sg13cmos5l_decap_8
XFILLER_16_114 VPWR VGND sg13cmos5l_decap_8
XFILLER_45_968 VPWR VGND sg13cmos5l_decap_8
XFILLER_13_821 VPWR VGND sg13cmos5l_decap_8
XFILLER_13_854 VPWR VGND sg13cmos5l_decap_4
XFILLER_8_302 VPWR VGND sg13cmos5l_decap_8
XFILLER_9_814 VPWR VGND sg13cmos5l_decap_8
XFILLER_12_331 VPWR VGND sg13cmos5l_decap_8
XFILLER_8_335 VPWR VGND sg13cmos5l_fill_1
XFILLER_12_386 VPWR VGND sg13cmos5l_decap_8
XFILLER_39_239 VPWR VGND sg13cmos5l_decap_8
X_2100_ _2100_/X _2404_/B _2100_/B VPWR VGND sg13cmos5l_or2_1
X_3080_ _3080_/Q clkload6/A _3080_/D fanout169/X VPWR VGND sg13cmos5l_dfrbpq_1
X_2031_ _2032_/C _2038_/B _2031_/B _2031_/C VPWR VGND sg13cmos5l_nand3_1
XFILLER_48_795 VPWR VGND sg13cmos5l_decap_8
XFILLER_47_261 VPWR VGND sg13cmos5l_decap_8
XFILLER_35_412 VPWR VGND sg13cmos5l_decap_8
XFILLER_36_957 VPWR VGND sg13cmos5l_decap_8
XFILLER_35_478 VPWR VGND sg13cmos5l_decap_8
XFILLER_23_629 VPWR VGND sg13cmos5l_decap_8
X_2933_ _2935_/C _3037_/Q _2933_/B VPWR VGND sg13cmos5l_xnor2_1
XFILLER_16_692 VPWR VGND sg13cmos5l_decap_8
XFILLER_31_640 VPWR VGND sg13cmos5l_decap_8
X_2864_ _2865_/B _3064_/Q _3065_/Q _2863_/C VPWR VGND sg13cmos5l_a21o_1
XFILLER_30_161 VPWR VGND sg13cmos5l_decap_8
X_2795_ _2804_/D _3034_/Q _3050_/Q VPWR VGND sg13cmos5l_xnor2_1
X_1815_ _3160_/A _3062_/Q _1815_/B VPWR VGND sg13cmos5l_and2_1
XFILLER_30_194 VPWR VGND sg13cmos5l_fill_2
Xhold302 hold302/X _2488_/Y VPWR VGND sg13cmos5l_dlygate4sd3_1
XFILLER_7_60 VPWR VGND sg13cmos5l_fill_2
X_1746_ _1746_/Y _1746_/A _1746_/B VPWR VGND sg13cmos5l_nand2_1
Xhold324 _3052_/D _2822_/Y VPWR VGND sg13cmos5l_dlygate4sd3_1
Xhold335 _3056_/D _2834_/Y VPWR VGND sg13cmos5l_dlygate4sd3_1
Xhold313 _2977_/D _2484_/Y VPWR VGND sg13cmos5l_dlygate4sd3_1
Xhold368 _2509_/B _2999_/Q VPWR VGND sg13cmos5l_dlygate4sd3_1
X_1677_ _1677_/Y _1771_/A _1562_/B _1662_/Y VPWR VGND sg13cmos5l_a21oi_1
Xhold357 _2881_/A _3070_/Q VPWR VGND sg13cmos5l_dlygate4sd3_1
Xhold346 _3074_/D _2897_/X VPWR VGND sg13cmos5l_dlygate4sd3_1
Xhold379 _3000_/D _2580_/X VPWR VGND sg13cmos5l_dlygate4sd3_1
X_2229_ _2232_/B _2229_/A _2229_/B VPWR VGND sg13cmos5l_nand2_1
XFILLER_27_913 VPWR VGND sg13cmos5l_decap_8
XFILLER_26_25 VPWR VGND sg13cmos5l_decap_8
XFILLER_42_938 VPWR VGND sg13cmos5l_decap_8
XFILLER_42_79 VPWR VGND sg13cmos5l_decap_8
XFILLER_5_338 VPWR VGND sg13cmos5l_decap_8
XFILLER_27_1011 VPWR VGND sg13cmos5l_decap_8
XFILLER_49_515 VPWR VGND sg13cmos5l_decap_8
XFILLER_49_559 VPWR VGND sg13cmos5l_decap_8
XFILLER_18_957 VPWR VGND sg13cmos5l_decap_8
XFILLER_29_283 VPWR VGND sg13cmos5l_decap_8
XFILLER_44_253 VPWR VGND sg13cmos5l_decap_4
XFILLER_17_467 VPWR VGND sg13cmos5l_decap_8
XFILLER_32_415 VPWR VGND sg13cmos5l_decap_8
XFILLER_44_297 VPWR VGND sg13cmos5l_decap_4
XFILLER_44_286 VPWR VGND sg13cmos5l_decap_8
XFILLER_33_949 VPWR VGND sg13cmos5l_decap_8
XFILLER_13_640 VPWR VGND sg13cmos5l_fill_2
XFILLER_13_651 VPWR VGND sg13cmos5l_decap_8
XFILLER_34_1015 VPWR VGND sg13cmos5l_decap_8
XFILLER_40_470 VPWR VGND sg13cmos5l_fill_2
XFILLER_9_633 VPWR VGND sg13cmos5l_decap_8
XFILLER_12_161 VPWR VGND sg13cmos5l_decap_8
XFILLER_40_492 VPWR VGND sg13cmos5l_decap_8
XFILLER_9_688 VPWR VGND sg13cmos5l_decap_8
X_1600_ _1660_/A _1745_/A _1600_/B VPWR VGND sg13cmos5l_nand2_1
X_2580_ _2580_/X _3009_/Q _2509_/A _2582_/S VPWR VGND sg13cmos5l_mux2_1
X_1531_ _1531_/Y _2977_/Q _2395_/A _1530_/Y VPWR VGND sg13cmos5l_a21oi_1
XFILLER_41_1008 VPWR VGND sg13cmos5l_decap_8
X_3132_ _3132_/Q _3134_/CLK _3132_/D fanout167/X VPWR VGND sg13cmos5l_dfrbpq_1
X_3063_ _3063_/Q _3136_/CLK _3063_/D fanout169/X VPWR VGND sg13cmos5l_dfrbpq_1
X_2014_ _2014_/Y _2003_/B _2297_/C _2013_/Y VPWR VGND sg13cmos5l_o21ai_1
XFILLER_24_916 VPWR VGND sg13cmos5l_decap_8
XFILLER_23_448 VPWR VGND sg13cmos5l_decap_8
X_2916_ _2943_/B _2916_/A _2922_/C VPWR VGND sg13cmos5l_nor2_1
X_2847_ _2847_/Y _2847_/A _2847_/B VPWR VGND sg13cmos5l_nor2_1
XFILLER_12_38 VPWR VGND sg13cmos5l_fill_1
X_2778_ _2779_/B _2778_/A _2778_/B VPWR VGND sg13cmos5l_xor2_1
X_1729_ _1729_/Y _1816_/A _1729_/B VPWR VGND sg13cmos5l_nand2_1
Xhold198 _3096_/D _3095_/Q VPWR VGND sg13cmos5l_dlygate4sd3_1
XFILLER_2_1013 VPWR VGND sg13cmos5l_decap_8
XFILLER_27_710 VPWR VGND sg13cmos5l_fill_2
XFILLER_37_79 VPWR VGND sg13cmos5l_decap_8
XFILLER_42_735 VPWR VGND sg13cmos5l_fill_1
XFILLER_41_201 VPWR VGND sg13cmos5l_decap_8
XFILLER_14_415 VPWR VGND sg13cmos5l_decap_4
XFILLER_15_949 VPWR VGND sg13cmos5l_decap_8
XFILLER_23_960 VPWR VGND sg13cmos5l_decap_8
XFILLER_6_625 VPWR VGND sg13cmos5l_decap_8
XFILLER_6_669 VPWR VGND sg13cmos5l_decap_8
XFILLER_5_135 VPWR VGND sg13cmos5l_decap_4
XFILLER_2_831 VPWR VGND sg13cmos5l_decap_8
XFILLER_49_345 VPWR VGND sg13cmos5l_decap_8
XFILLER_49_378 VPWR VGND sg13cmos5l_decap_8
XFILLER_18_754 VPWR VGND sg13cmos5l_decap_8
XFILLER_45_540 VPWR VGND sg13cmos5l_fill_1
XFILLER_33_713 VPWR VGND sg13cmos5l_decap_4
XFILLER_45_584 VPWR VGND sg13cmos5l_decap_8
XFILLER_17_275 VPWR VGND sg13cmos5l_decap_8
XFILLER_14_982 VPWR VGND sg13cmos5l_decap_8
XFILLER_20_407 VPWR VGND sg13cmos5l_fill_1
X_2701_ _2701_/Y _2696_/Y _2699_/X _2700_/Y VPWR VGND sg13cmos5l_o21ai_1
XFILLER_9_474 VPWR VGND sg13cmos5l_decap_8
XFILLER_9_485 VPWR VGND sg13cmos5l_fill_2
X_2632_ _2632_/Y _2672_/A _2446_/B _2620_/Y VPWR VGND sg13cmos5l_a21oi_1
X_2563_ _2564_/B _3007_/Q _3006_/Q VPWR VGND sg13cmos5l_xor2_1
X_1514_ _2966_/A _3087_/Q VPWR VGND sg13cmos5l_inv_1
X_2494_ _2509_/C _2494_/A _2494_/B VPWR VGND sg13cmos5l_nor2_1
XFILLER_4_94 VPWR VGND sg13cmos5l_decap_8
X_3115_ _3115_/Q _3117_/CLK _3115_/D fanout149/X VPWR VGND sg13cmos5l_dfrbpq_1
X_3046_ _3046_/Q _3057_/CLK _3046_/D fanout172/X VPWR VGND sg13cmos5l_dfrbpq_1
XFILLER_36_562 VPWR VGND sg13cmos5l_decap_8
XFILLER_24_713 VPWR VGND sg13cmos5l_decap_8
XFILLER_12_919 VPWR VGND sg13cmos5l_decap_8
XFILLER_23_267 VPWR VGND sg13cmos5l_decap_8
XFILLER_23_289 VPWR VGND sg13cmos5l_fill_1
XFILLER_20_952 VPWR VGND sg13cmos5l_decap_8
XFILLER_48_56 VPWR VGND sg13cmos5l_decap_8
XFILLER_24_1014 VPWR VGND sg13cmos5l_decap_8
XFILLER_46_337 VPWR VGND sg13cmos5l_decap_8
XFILLER_14_212 VPWR VGND sg13cmos5l_fill_2
XFILLER_15_713 VPWR VGND sg13cmos5l_decap_8
XFILLER_27_595 VPWR VGND sg13cmos5l_fill_2
XFILLER_9_39 VPWR VGND sg13cmos5l_decap_8
Xfanout82 _2778_/B _2672_/Y VPWR VGND sg13cmos5l_buf_1
Xfanout71 _2205_/A _1838_/Y VPWR VGND sg13cmos5l_buf_1
Xfanout60 _2186_/B _2037_/A VPWR VGND sg13cmos5l_buf_1
Xfanout93 _2856_/B _1500_/Y VPWR VGND sg13cmos5l_buf_1
XFILLER_7_923 VPWR VGND sg13cmos5l_decap_8
XFILLER_11_985 VPWR VGND sg13cmos5l_decap_8
XFILLER_31_1018 VPWR VGND sg13cmos5l_decap_8
XFILLER_10_473 VPWR VGND sg13cmos5l_decap_8
XFILLER_10_484 VPWR VGND sg13cmos5l_fill_2
XFILLER_6_455 VPWR VGND sg13cmos5l_decap_8
XFILLER_49_153 VPWR VGND sg13cmos5l_fill_2
XFILLER_38_827 VPWR VGND sg13cmos5l_decap_8
XFILLER_49_186 VPWR VGND sg13cmos5l_decap_8
XFILLER_18_562 VPWR VGND sg13cmos5l_decap_8
XFILLER_33_521 VPWR VGND sg13cmos5l_decap_4
X_1994_ _1994_/Y _1979_/Y _1984_/Y _1987_/Y _1993_/X VPWR VGND sg13cmos5l_a22oi_1
XFILLER_20_215 VPWR VGND sg13cmos5l_decap_4
XFILLER_20_237 VPWR VGND sg13cmos5l_decap_8
XFILLER_9_293 VPWR VGND sg13cmos5l_decap_8
X_2615_ _3022_/D _2615_/A _2615_/B VPWR VGND sg13cmos5l_nor2_1
XFILLER_47_1014 VPWR VGND sg13cmos5l_decap_8
X_2546_ _2546_/Y _2545_/A _2568_/A _2592_/S _2545_/X VPWR VGND sg13cmos5l_a22oi_1
X_2477_ _2477_/Y _2477_/A _2480_/B VPWR VGND sg13cmos5l_nor2_1
X_3029_ _3029_/Q _3101_/CLK _3029_/D fanout157/X VPWR VGND sg13cmos5l_dfrbpq_1
XFILLER_34_14 VPWR VGND sg13cmos5l_decap_8
XFILLER_34_25 VPWR VGND sg13cmos5l_fill_2
XFILLER_12_738 VPWR VGND sg13cmos5l_fill_2
XFILLER_11_215 VPWR VGND sg13cmos5l_decap_8
XFILLER_24_598 VPWR VGND sg13cmos5l_decap_8
Xclkload2 clkload2/Y clkload2/A VPWR VGND sg13cmos5l_inv_1
XFILLER_4_937 VPWR VGND sg13cmos5l_decap_8
XFILLER_3_425 VPWR VGND sg13cmos5l_decap_8
XFILLER_19_348 VPWR VGND sg13cmos5l_fill_2
XFILLER_47_679 VPWR VGND sg13cmos5l_decap_8
XFILLER_28_860 VPWR VGND sg13cmos5l_decap_8
XFILLER_46_189 VPWR VGND sg13cmos5l_decap_8
XFILLER_15_532 VPWR VGND sg13cmos5l_decap_8
XFILLER_43_885 VPWR VGND sg13cmos5l_decap_8
XFILLER_42_395 VPWR VGND sg13cmos5l_decap_4
XFILLER_11_760 VPWR VGND sg13cmos5l_decap_8
XFILLER_7_720 VPWR VGND sg13cmos5l_decap_8
XFILLER_7_797 VPWR VGND sg13cmos5l_decap_8
X_2400_ _2594_/B _2412_/C _2401_/B _2401_/C _2401_/D VPWR VGND sg13cmos5l_nor4_1
X_2331_ _2609_/A _2331_/A _2596_/C VPWR VGND sg13cmos5l_nand2_1
X_2262_ _2263_/B _2258_/Y _2260_/Y _2261_/Y VPWR VGND sg13cmos5l_o21ai_1
X_2193_ _2194_/C _2057_/B _2221_/A _2108_/A VPWR VGND sg13cmos5l_a21oi_1
XFILLER_38_679 VPWR VGND sg13cmos5l_decap_8
XFILLER_26_819 VPWR VGND sg13cmos5l_decap_8
XFILLER_18_392 VPWR VGND sg13cmos5l_decap_8
XFILLER_34_852 VPWR VGND sg13cmos5l_fill_2
XFILLER_34_896 VPWR VGND sg13cmos5l_decap_8
XFILLER_21_524 VPWR VGND sg13cmos5l_decap_8
XFILLER_14_1024 VPWR VGND sg13cmos5l_decap_4
X_1977_ _1977_/Y _2131_/B _2251_/C _1985_/B VPWR VGND sg13cmos5l_a21oi_1
X_2529_ _2529_/Y _2529_/A _2529_/B VPWR VGND sg13cmos5l_nor2_1
XFILLER_0_439 VPWR VGND sg13cmos5l_decap_8
XFILLER_29_25 VPWR VGND sg13cmos5l_decap_8
XFILLER_29_58 VPWR VGND sg13cmos5l_fill_1
XFILLER_29_613 VPWR VGND sg13cmos5l_decap_8
XFILLER_28_112 VPWR VGND sg13cmos5l_decap_8
XFILLER_29_635 VPWR VGND sg13cmos5l_decap_8
XFILLER_17_808 VPWR VGND sg13cmos5l_decap_8
XFILLER_45_35 VPWR VGND sg13cmos5l_fill_1
XFILLER_43_115 VPWR VGND sg13cmos5l_fill_1
XFILLER_28_189 VPWR VGND sg13cmos5l_decap_8
XFILLER_45_57 VPWR VGND sg13cmos5l_decap_8
XFILLER_24_384 VPWR VGND sg13cmos5l_decap_4
XFILLER_24_395 VPWR VGND sg13cmos5l_decap_8
XFILLER_40_888 VPWR VGND sg13cmos5l_fill_1
XFILLER_8_517 VPWR VGND sg13cmos5l_fill_1
XFILLER_4_734 VPWR VGND sg13cmos5l_decap_8
XFILLER_3_211 VPWR VGND sg13cmos5l_decap_8
XFILLER_10_60 VPWR VGND sg13cmos5l_fill_1
XFILLER_48_900 VPWR VGND sg13cmos5l_decap_8
XFILLER_47_432 VPWR VGND sg13cmos5l_fill_1
XFILLER_47_421 VPWR VGND sg13cmos5l_decap_8
XFILLER_48_977 VPWR VGND sg13cmos5l_decap_8
XFILLER_47_443 VPWR VGND sg13cmos5l_decap_8
XFILLER_19_145 VPWR VGND sg13cmos5l_decap_8
XFILLER_47_476 VPWR VGND sg13cmos5l_decap_8
XFILLER_19_189 VPWR VGND sg13cmos5l_decap_8
XFILLER_34_137 VPWR VGND sg13cmos5l_decap_8
XFILLER_37_1024 VPWR VGND sg13cmos5l_decap_4
XFILLER_16_863 VPWR VGND sg13cmos5l_decap_8
X_1900_ _1901_/B _1845_/A _1845_/B _2011_/D _1862_/A _1853_/Y VPWR VGND sg13cmos5l_a221oi_1
X_2880_ _2885_/B _3068_/Q _3069_/Q _3070_/Q _2880_/D VPWR VGND sg13cmos5l_nand4_1
XFILLER_30_310 VPWR VGND sg13cmos5l_fill_2
XFILLER_30_321 VPWR VGND sg13cmos5l_fill_2
X_1831_ _2332_/C _2331_/A _2605_/A _1831_/C VPWR VGND sg13cmos5l_and3_1
XFILLER_30_332 VPWR VGND sg13cmos5l_decap_8
XFILLER_30_376 VPWR VGND sg13cmos5l_decap_4
XFILLER_31_899 VPWR VGND sg13cmos5l_decap_8
X_1762_ _1762_/X _2596_/A _1762_/B VPWR VGND sg13cmos5l_or2_1
X_1693_ _1738_/C _1693_/A _1693_/B VPWR VGND sg13cmos5l_nand2_1
X_2314_ _2314_/Y _2118_/B _1966_/B _2148_/A VPWR VGND sg13cmos5l_a21oi_1
XFILLER_39_933 VPWR VGND sg13cmos5l_decap_8
X_2245_ _2245_/Y _2063_/A _1884_/Y _2178_/B _2244_/Y _2242_/A VPWR VGND sg13cmos5l_a221oi_1
X_2176_ _2177_/C _1883_/Y _2173_/Y _2175_/Y VPWR VGND sg13cmos5l_o21ai_1
XFILLER_38_498 VPWR VGND sg13cmos5l_decap_4
XFILLER_25_126 VPWR VGND sg13cmos5l_decap_8
XFILLER_41_608 VPWR VGND sg13cmos5l_fill_1
XFILLER_22_800 VPWR VGND sg13cmos5l_decap_8
XFILLER_34_682 VPWR VGND sg13cmos5l_decap_8
XFILLER_22_888 VPWR VGND sg13cmos5l_decap_4
XFILLER_21_365 VPWR VGND sg13cmos5l_decap_8
XFILLER_0_214 VPWR VGND sg13cmos5l_decap_8
XFILLER_1_737 VPWR VGND sg13cmos5l_decap_8
XFILLER_0_269 VPWR VGND sg13cmos5l_decap_8
XFILLER_5_1000 VPWR VGND sg13cmos5l_decap_8
XFILLER_45_947 VPWR VGND sg13cmos5l_decap_8
XFILLER_44_413 VPWR VGND sg13cmos5l_fill_2
XFILLER_17_627 VPWR VGND sg13cmos5l_decap_8
XFILLER_29_498 VPWR VGND sg13cmos5l_fill_1
XFILLER_44_457 VPWR VGND sg13cmos5l_fill_1
XFILLER_16_159 VPWR VGND sg13cmos5l_decap_8
XFILLER_12_310 VPWR VGND sg13cmos5l_decap_8
XFILLER_40_685 VPWR VGND sg13cmos5l_decap_8
XFILLER_8_358 VPWR VGND sg13cmos5l_fill_2
XFILLER_8_347 VPWR VGND sg13cmos5l_decap_8
XFILLER_21_92 VPWR VGND sg13cmos5l_decap_8
XFILLER_39_218 VPWR VGND sg13cmos5l_decap_8
X_2030_ _2031_/C _2402_/A _2078_/B VPWR VGND sg13cmos5l_nor2_1
XFILLER_36_936 VPWR VGND sg13cmos5l_decap_8
X_2932_ _2935_/B _3040_/Q _2926_/Y _2949_/B VPWR VGND sg13cmos5l_a21oi_1
X_2863_ _2869_/B _3064_/Q _3065_/Q _2863_/C VPWR VGND sg13cmos5l_nand3_1
XFILLER_31_674 VPWR VGND sg13cmos5l_decap_8
XFILLER_31_696 VPWR VGND sg13cmos5l_decap_4
X_2794_ _2804_/C _3043_/Q _2842_/A VPWR VGND sg13cmos5l_xnor2_1
X_1814_ _1815_/B _1814_/A _1814_/B _1814_/C _1814_/D VPWR VGND sg13cmos5l_nand4_1
X_1745_ _1746_/B _1745_/A _1745_/B _1745_/C VPWR VGND sg13cmos5l_nand3_1
XFILLER_11_1027 VPWR VGND sg13cmos5l_fill_2
Xhold325 _2836_/A _3057_/Q VPWR VGND sg13cmos5l_dlygate4sd3_1
Xhold303 _2979_/D _2489_/Y VPWR VGND sg13cmos5l_dlygate4sd3_1
XFILLER_7_380 VPWR VGND sg13cmos5l_decap_8
Xhold314 _2437_/A _3093_/Q VPWR VGND sg13cmos5l_dlygate4sd3_1
Xhold369 _2999_/D _2579_/X VPWR VGND sg13cmos5l_dlygate4sd3_1
Xhold347 _2384_/A _3118_/Q VPWR VGND sg13cmos5l_dlygate4sd3_1
X_1676_ _1676_/Y _1676_/A _1676_/B _1676_/C VPWR VGND sg13cmos5l_nor3_1
Xhold358 _3070_/D _2882_/Y VPWR VGND sg13cmos5l_dlygate4sd3_1
Xhold336 _1520_/A _3027_/Q VPWR VGND sg13cmos5l_dlygate4sd3_1
XFILLER_39_752 VPWR VGND sg13cmos5l_decap_8
XFILLER_39_796 VPWR VGND sg13cmos5l_decap_8
XFILLER_39_774 VPWR VGND sg13cmos5l_fill_2
X_2228_ _2229_/B _2241_/A _2228_/B VPWR VGND sg13cmos5l_nor2_1
X_2159_ _2160_/C _2199_/A _2134_/Y _2158_/Y VPWR VGND sg13cmos5l_a21oi_1
XFILLER_26_446 VPWR VGND sg13cmos5l_decap_4
XFILLER_27_969 VPWR VGND sg13cmos5l_decap_8
XFILLER_42_917 VPWR VGND sg13cmos5l_decap_8
XFILLER_14_619 VPWR VGND sg13cmos5l_fill_1
XFILLER_13_118 VPWR VGND sg13cmos5l_decap_4
XFILLER_13_129 VPWR VGND sg13cmos5l_decap_8
XFILLER_22_685 VPWR VGND sg13cmos5l_fill_1
XFILLER_5_317 VPWR VGND sg13cmos5l_decap_8
XFILLER_1_501 VPWR VGND sg13cmos5l_decap_4
XFILLER_1_545 VPWR VGND sg13cmos5l_fill_1
XFILLER_18_936 VPWR VGND sg13cmos5l_decap_8
XFILLER_29_262 VPWR VGND sg13cmos5l_decap_8
XFILLER_45_755 VPWR VGND sg13cmos5l_fill_1
XFILLER_45_744 VPWR VGND sg13cmos5l_decap_8
XFILLER_17_424 VPWR VGND sg13cmos5l_fill_2
XFILLER_45_777 VPWR VGND sg13cmos5l_fill_2
XFILLER_33_928 VPWR VGND sg13cmos5l_decap_8
XFILLER_45_799 VPWR VGND sg13cmos5l_decap_8
XFILLER_41_994 VPWR VGND sg13cmos5l_decap_8
XFILLER_8_111 VPWR VGND sg13cmos5l_fill_1
XFILLER_8_100 VPWR VGND sg13cmos5l_decap_8
XFILLER_12_140 VPWR VGND sg13cmos5l_decap_8
XFILLER_4_361 VPWR VGND sg13cmos5l_fill_1
XFILLER_4_350 VPWR VGND sg13cmos5l_decap_4
X_1530_ _1530_/Y _2395_/A _1530_/B _1530_/C _1530_/D VPWR VGND sg13cmos5l_nor4_1
XFILLER_5_895 VPWR VGND sg13cmos5l_decap_8
X_3131_ _3131_/Q _3134_/CLK _3131_/D fanout177/X VPWR VGND sg13cmos5l_dfrbpq_1
X_3062_ _3062_/Q _3136_/CLK _3062_/D fanout164/X VPWR VGND sg13cmos5l_dfrbpq_1
X_2013_ _2013_/Y _2231_/A _2013_/B VPWR VGND sg13cmos5l_nand2_1
XFILLER_35_276 VPWR VGND sg13cmos5l_decap_8
XFILLER_17_991 VPWR VGND sg13cmos5l_decap_8
X_2915_ _3079_/D _2914_/A _2913_/A _2914_/Y VPWR VGND sg13cmos5l_o21ai_1
XFILLER_32_983 VPWR VGND sg13cmos5l_decap_8
X_2846_ _3060_/D _2850_/B _2846_/B _2847_/B VPWR VGND sg13cmos5l_nor3_1
XFILLER_31_482 VPWR VGND sg13cmos5l_decap_8
X_2777_ _2779_/A _2771_/Y _2772_/Y _2770_/Y VPWR VGND sg13cmos5l_o21ai_1
X_1728_ _1728_/Y _1728_/A VPWR VGND sg13cmos5l_inv_1
X_1659_ _1745_/B _2246_/A _1659_/B VPWR VGND sg13cmos5l_nand2_1
Xhold199 _3100_/D _3099_/Q VPWR VGND sg13cmos5l_dlygate4sd3_1
XFILLER_15_928 VPWR VGND sg13cmos5l_decap_8
XFILLER_26_254 VPWR VGND sg13cmos5l_fill_1
XFILLER_26_298 VPWR VGND sg13cmos5l_decap_8
XFILLER_42_758 VPWR VGND sg13cmos5l_fill_2
XFILLER_22_471 VPWR VGND sg13cmos5l_decap_8
XFILLER_6_648 VPWR VGND sg13cmos5l_decap_8
XFILLER_2_810 VPWR VGND sg13cmos5l_decap_8
XFILLER_1_331 VPWR VGND sg13cmos5l_decap_4
XFILLER_49_324 VPWR VGND sg13cmos5l_decap_8
XFILLER_2_887 VPWR VGND sg13cmos5l_decap_8
XFILLER_17_221 VPWR VGND sg13cmos5l_decap_8
XFILLER_18_733 VPWR VGND sg13cmos5l_decap_8
XFILLER_45_563 VPWR VGND sg13cmos5l_decap_8
XFILLER_17_232 VPWR VGND sg13cmos5l_fill_1
XFILLER_32_213 VPWR VGND sg13cmos5l_decap_8
XFILLER_32_246 VPWR VGND sg13cmos5l_decap_8
XFILLER_33_769 VPWR VGND sg13cmos5l_fill_2
XFILLER_14_961 VPWR VGND sg13cmos5l_decap_8
X_2700_ _2700_/Y _2696_/Y _2699_/X _2855_/A VPWR VGND sg13cmos5l_a21oi_1
XFILLER_9_453 VPWR VGND sg13cmos5l_decap_8
X_2631_ _2631_/Y _1520_/Y _2630_/Y _2628_/B VPWR VGND sg13cmos5l_a21oi_1
X_2562_ _2564_/A _3010_/Q _3011_/Q VPWR VGND sg13cmos5l_xnor2_1
XFILLER_5_692 VPWR VGND sg13cmos5l_decap_8
X_1513_ _2914_/A _1513_/A VPWR VGND sg13cmos5l_inv_1
X_2493_ _2499_/C _2995_/Q _2512_/B VPWR VGND sg13cmos5l_nor2_1
XFILLER_4_191 VPWR VGND sg13cmos5l_decap_8
X_3114_ _3114_/Q clkload0/A _3114_/D fanout149/X VPWR VGND sg13cmos5l_dfrbpq_1
X_3045_ _3045_/Q _3060_/CLK _3045_/D fanout175/X VPWR VGND sg13cmos5l_dfrbpq_1
XFILLER_23_27 VPWR VGND sg13cmos5l_decap_8
XFILLER_20_931 VPWR VGND sg13cmos5l_decap_8
XFILLER_23_38 VPWR VGND sg13cmos5l_fill_1
Xclkbuf_5_18__f_clk _3136_/CLK clkbuf_4_9_0_clk/X VPWR VGND sg13cmos5l_buf_8
X_2829_ _2831_/B _2830_/A _2830_/B VPWR VGND sg13cmos5l_nor2_1
XFILLER_3_8 VPWR VGND sg13cmos5l_fill_1
XFILLER_48_46 VPWR VGND sg13cmos5l_fill_1
XFILLER_47_839 VPWR VGND sg13cmos5l_decap_8
XFILLER_46_305 VPWR VGND sg13cmos5l_decap_8
XFILLER_27_541 VPWR VGND sg13cmos5l_decap_8
XFILLER_9_18 VPWR VGND sg13cmos5l_decap_8
XFILLER_15_769 VPWR VGND sg13cmos5l_decap_8
XFILLER_14_268 VPWR VGND sg13cmos5l_decap_4
XFILLER_30_706 VPWR VGND sg13cmos5l_decap_4
XFILLER_42_599 VPWR VGND sg13cmos5l_decap_8
Xfanout72 _2032_/A _2113_/A VPWR VGND sg13cmos5l_buf_1
Xfanout50 _1907_/A _2308_/B VPWR VGND sg13cmos5l_buf_1
Xfanout61 _2108_/A _2037_/A VPWR VGND sg13cmos5l_buf_1
XFILLER_23_780 VPWR VGND sg13cmos5l_fill_2
XFILLER_23_791 VPWR VGND sg13cmos5l_fill_2
Xfanout83 _2459_/A _2444_/X VPWR VGND sg13cmos5l_buf_1
XFILLER_7_902 VPWR VGND sg13cmos5l_decap_8
Xfanout94 _2322_/A _1496_/Y VPWR VGND sg13cmos5l_buf_1
XFILLER_10_430 VPWR VGND sg13cmos5l_decap_8
XFILLER_10_441 VPWR VGND sg13cmos5l_fill_1
XFILLER_11_964 VPWR VGND sg13cmos5l_decap_8
XFILLER_13_60 VPWR VGND sg13cmos5l_decap_4
XFILLER_7_979 VPWR VGND sg13cmos5l_decap_8
XFILLER_43_9 VPWR VGND sg13cmos5l_fill_1
XFILLER_2_684 VPWR VGND sg13cmos5l_decap_8
XFILLER_49_132 VPWR VGND sg13cmos5l_decap_8
XFILLER_49_165 VPWR VGND sg13cmos5l_decap_8
XFILLER_18_530 VPWR VGND sg13cmos5l_fill_1
XFILLER_18_541 VPWR VGND sg13cmos5l_decap_8
XFILLER_46_883 VPWR VGND sg13cmos5l_decap_8
XFILLER_33_533 VPWR VGND sg13cmos5l_decap_8
XFILLER_33_577 VPWR VGND sg13cmos5l_decap_8
X_1993_ _1993_/X _2232_/A _1993_/B _1993_/C VPWR VGND sg13cmos5l_and3_1
XFILLER_21_739 VPWR VGND sg13cmos5l_decap_8
X_2614_ _2614_/X _2614_/A _2614_/B VPWR VGND sg13cmos5l_xor2_1
X_2545_ _2545_/X _2545_/A _2990_/Q VPWR VGND sg13cmos5l_xor2_1
X_2476_ _2476_/Y _2977_/Q _2459_/A _2635_/A _2468_/Y VPWR VGND sg13cmos5l_a22oi_1
XFILLER_18_27 VPWR VGND sg13cmos5l_decap_4
XFILLER_18_49 VPWR VGND sg13cmos5l_decap_4
XFILLER_29_839 VPWR VGND sg13cmos5l_decap_8
XFILLER_37_883 VPWR VGND sg13cmos5l_fill_1
X_3028_ _3028_/Q clkload2/A _3028_/D fanout155/X VPWR VGND sg13cmos5l_dfrbpq_1
XFILLER_24_500 VPWR VGND sg13cmos5l_fill_1
XFILLER_36_382 VPWR VGND sg13cmos5l_fill_2
XFILLER_24_577 VPWR VGND sg13cmos5l_decap_8
Xclkload3 clkload3/Y clkload3/A VPWR VGND sg13cmos5l_inv_1
XFILLER_20_783 VPWR VGND sg13cmos5l_decap_8
XFILLER_4_916 VPWR VGND sg13cmos5l_decap_8
XFILLER_3_404 VPWR VGND sg13cmos5l_decap_8
XFILLER_46_124 VPWR VGND sg13cmos5l_decap_4
XFILLER_19_327 VPWR VGND sg13cmos5l_decap_8
XFILLER_47_669 VPWR VGND sg13cmos5l_fill_1
XFILLER_35_809 VPWR VGND sg13cmos5l_decap_8
XFILLER_15_511 VPWR VGND sg13cmos5l_decap_8
XFILLER_15_522 VPWR VGND sg13cmos5l_fill_2
XFILLER_15_588 VPWR VGND sg13cmos5l_decap_8
XFILLER_15_599 VPWR VGND sg13cmos5l_fill_2
XFILLER_7_776 VPWR VGND sg13cmos5l_decap_8
XFILLER_10_293 VPWR VGND sg13cmos5l_decap_8
XFILLER_6_297 VPWR VGND sg13cmos5l_decap_8
X_2330_ _2337_/A _2401_/B _2440_/A _3112_/Q VPWR VGND sg13cmos5l_o21ai_1
XFILLER_2_481 VPWR VGND sg13cmos5l_fill_2
X_2261_ _2261_/Y _1952_/D _2280_/A _2241_/Y VPWR VGND sg13cmos5l_a21oi_1
XFILLER_27_4 VPWR VGND sg13cmos5l_decap_8
XFILLER_37_124 VPWR VGND sg13cmos5l_decap_4
X_2192_ _2197_/A _1866_/Y _2297_/B _2181_/Y VPWR VGND sg13cmos5l_o21ai_1
XFILLER_19_850 VPWR VGND sg13cmos5l_decap_8
XFILLER_18_371 VPWR VGND sg13cmos5l_decap_8
XFILLER_25_308 VPWR VGND sg13cmos5l_fill_2
XFILLER_34_864 VPWR VGND sg13cmos5l_decap_4
XFILLER_34_875 VPWR VGND sg13cmos5l_decap_8
XFILLER_33_385 VPWR VGND sg13cmos5l_decap_8
XFILLER_14_1003 VPWR VGND sg13cmos5l_decap_8
X_1976_ _1976_/Y _2131_/B _2251_/C VPWR VGND sg13cmos5l_nand2_1
X_2528_ _2528_/Y _2528_/A _2529_/B VPWR VGND sg13cmos5l_nor2_1
XFILLER_0_418 VPWR VGND sg13cmos5l_decap_8
XFILLER_1_919 VPWR VGND sg13cmos5l_decap_8
X_2459_ _2460_/B _2459_/A _2635_/B VPWR VGND sg13cmos5l_nor2_1
XFILLER_21_1018 VPWR VGND sg13cmos5l_decap_8
XFILLER_29_669 VPWR VGND sg13cmos5l_decap_8
XFILLER_28_168 VPWR VGND sg13cmos5l_decap_8
XFILLER_24_363 VPWR VGND sg13cmos5l_decap_8
XFILLER_12_558 VPWR VGND sg13cmos5l_decap_4
XFILLER_4_713 VPWR VGND sg13cmos5l_decap_8
XFILLER_0_985 VPWR VGND sg13cmos5l_decap_8
XFILLER_48_956 VPWR VGND sg13cmos5l_decap_8
XFILLER_19_81 VPWR VGND sg13cmos5l_fill_2
XFILLER_19_124 VPWR VGND sg13cmos5l_fill_1
XFILLER_35_606 VPWR VGND sg13cmos5l_decap_4
XFILLER_34_105 VPWR VGND sg13cmos5l_decap_8
XFILLER_16_831 VPWR VGND sg13cmos5l_decap_8
XFILLER_37_1003 VPWR VGND sg13cmos5l_decap_8
XFILLER_15_352 VPWR VGND sg13cmos5l_fill_1
X_1830_ _1830_/Y _2605_/A _2605_/B _1919_/B VPWR VGND sg13cmos5l_nand3_1
XFILLER_30_355 VPWR VGND sg13cmos5l_decap_8
XFILLER_31_867 VPWR VGND sg13cmos5l_fill_2
XFILLER_31_878 VPWR VGND sg13cmos5l_decap_8
XFILLER_11_591 VPWR VGND sg13cmos5l_decap_8
X_1761_ _1764_/B _1753_/Y _1756_/Y _1760_/Y VPWR VGND sg13cmos5l_o21ai_1
X_1692_ _1701_/B _1684_/Y _1685_/Y _1689_/Y _1691_/Y _1705_/C VPWR VGND sg13cmos5l_a221oi_1
X_2313_ _2322_/C _2310_/X _2312_/Y _2032_/A VPWR VGND sg13cmos5l_a21oi_1
XFILLER_39_912 VPWR VGND sg13cmos5l_decap_8
X_2244_ _2244_/Y _2244_/A _2244_/B _2244_/C VPWR VGND sg13cmos5l_nand3_1
X_2175_ _2175_/Y _2175_/A _2175_/B _2175_/C VPWR VGND sg13cmos5l_nor3_1
XFILLER_39_989 VPWR VGND sg13cmos5l_decap_8
XFILLER_38_477 VPWR VGND sg13cmos5l_decap_8
XFILLER_34_661 VPWR VGND sg13cmos5l_decap_8
XFILLER_33_171 VPWR VGND sg13cmos5l_fill_2
XFILLER_21_344 VPWR VGND sg13cmos5l_decap_8
XFILLER_33_193 VPWR VGND sg13cmos5l_decap_8
X_1959_ _1959_/Y _2297_/C _1958_/X _1982_/A VPWR VGND sg13cmos5l_a21oi_1
XFILLER_31_27 VPWR VGND sg13cmos5l_decap_8
XFILLER_1_716 VPWR VGND sg13cmos5l_decap_8
XFILLER_49_709 VPWR VGND sg13cmos5l_decap_8
XFILLER_0_248 VPWR VGND sg13cmos5l_decap_8
XFILLER_45_926 VPWR VGND sg13cmos5l_decap_8
XFILLER_16_138 VPWR VGND sg13cmos5l_decap_8
XFILLER_13_801 VPWR VGND sg13cmos5l_fill_1
XFILLER_32_609 VPWR VGND sg13cmos5l_decap_8
XFILLER_25_694 VPWR VGND sg13cmos5l_decap_8
XFILLER_40_642 VPWR VGND sg13cmos5l_decap_8
XFILLER_13_878 VPWR VGND sg13cmos5l_fill_1
XFILLER_24_193 VPWR VGND sg13cmos5l_decap_8
XFILLER_8_326 VPWR VGND sg13cmos5l_decap_8
XFILLER_9_849 VPWR VGND sg13cmos5l_decap_8
XFILLER_12_366 VPWR VGND sg13cmos5l_decap_8
XFILLER_12_377 VPWR VGND sg13cmos5l_fill_1
XFILLER_4_510 VPWR VGND sg13cmos5l_decap_4
XFILLER_0_782 VPWR VGND sg13cmos5l_decap_8
XFILLER_36_915 VPWR VGND sg13cmos5l_decap_8
XFILLER_44_981 VPWR VGND sg13cmos5l_decap_8
X_2931_ _2949_/B _3042_/Q _3043_/Q _3044_/Q _3045_/Q VPWR VGND sg13cmos5l_or4_1
XFILLER_16_683 VPWR VGND sg13cmos5l_decap_4
Xclkbuf_0_clk clkbuf_0_clk/X clk VPWR VGND sg13cmos5l_buf_8
X_2862_ _2862_/Y _2863_/C _2879_/B VPWR VGND sg13cmos5l_nand2_1
X_2793_ _2800_/C _3040_/Q _3056_/Q VPWR VGND sg13cmos5l_xnor2_1
X_1813_ _1814_/D _1813_/A _1813_/B _1813_/C VPWR VGND sg13cmos5l_nor3_1
XFILLER_7_73 VPWR VGND sg13cmos5l_decap_4
XFILLER_7_62 VPWR VGND sg13cmos5l_fill_1
X_1744_ _1745_/C _3130_/Q _1852_/B _1744_/C VPWR VGND sg13cmos5l_nand3_1
XFILLER_11_1006 VPWR VGND sg13cmos5l_decap_8
Xhold304 _2847_/A _3061_/Q VPWR VGND sg13cmos5l_dlygate4sd3_1
Xhold326 _2837_/B _2835_/Y VPWR VGND sg13cmos5l_dlygate4sd3_1
XFILLER_8_893 VPWR VGND sg13cmos5l_decap_8
XFILLER_7_392 VPWR VGND sg13cmos5l_decap_8
Xhold315 _2438_/B _2437_/X VPWR VGND sg13cmos5l_dlygate4sd3_1
Xhold348 _2830_/A _3055_/Q VPWR VGND sg13cmos5l_dlygate4sd3_1
X_1675_ _1676_/C _1722_/B _1674_/Y _3127_/Q VPWR VGND sg13cmos5l_o21ai_1
Xhold359 _2875_/B _3069_/Q VPWR VGND sg13cmos5l_dlygate4sd3_1
Xhold337 _3027_/D _2631_/Y VPWR VGND sg13cmos5l_dlygate4sd3_1
X_2227_ _2228_/B _2227_/A _2227_/B VPWR VGND sg13cmos5l_nor2_1
XFILLER_38_296 VPWR VGND sg13cmos5l_decap_8
XFILLER_38_285 VPWR VGND sg13cmos5l_decap_4
X_2158_ _2158_/Y _2404_/B _2158_/B _2158_/C VPWR VGND sg13cmos5l_nand3_1
XFILLER_26_425 VPWR VGND sg13cmos5l_decap_8
XFILLER_27_948 VPWR VGND sg13cmos5l_decap_8
X_2089_ _2089_/Y _2412_/C _2089_/B _2089_/C _2089_/D VPWR VGND sg13cmos5l_nand4_1
XFILLER_26_469 VPWR VGND sg13cmos5l_decap_4
XFILLER_41_417 VPWR VGND sg13cmos5l_decap_8
XFILLER_35_992 VPWR VGND sg13cmos5l_decap_8
XFILLER_21_130 VPWR VGND sg13cmos5l_decap_8
XFILLER_42_37 VPWR VGND sg13cmos5l_decap_8
XFILLER_10_804 VPWR VGND sg13cmos5l_decap_4
XFILLER_21_196 VPWR VGND sg13cmos5l_fill_2
XFILLER_22_697 VPWR VGND sg13cmos5l_fill_2
XFILLER_17_403 VPWR VGND sg13cmos5l_decap_8
XFILLER_18_915 VPWR VGND sg13cmos5l_decap_8
XFILLER_29_241 VPWR VGND sg13cmos5l_decap_8
XFILLER_44_211 VPWR VGND sg13cmos5l_decap_8
XFILLER_33_907 VPWR VGND sg13cmos5l_decap_8
XFILLER_13_642 VPWR VGND sg13cmos5l_fill_1
XFILLER_16_93 VPWR VGND sg13cmos5l_decap_8
XFILLER_25_491 VPWR VGND sg13cmos5l_fill_2
XFILLER_41_973 VPWR VGND sg13cmos5l_decap_8
XFILLER_40_472 VPWR VGND sg13cmos5l_fill_1
XFILLER_40_461 VPWR VGND sg13cmos5l_fill_2
XFILLER_13_686 VPWR VGND sg13cmos5l_fill_1
XFILLER_8_145 VPWR VGND sg13cmos5l_decap_8
XFILLER_9_668 VPWR VGND sg13cmos5l_decap_4
XFILLER_12_196 VPWR VGND sg13cmos5l_decap_8
XFILLER_32_81 VPWR VGND sg13cmos5l_decap_8
XFILLER_8_189 VPWR VGND sg13cmos5l_fill_1
XFILLER_5_874 VPWR VGND sg13cmos5l_decap_8
XFILLER_4_340 VPWR VGND sg13cmos5l_fill_2
XFILLER_4_373 VPWR VGND sg13cmos5l_fill_2
X_3130_ _3130_/Q _3135_/CLK _3130_/D fanout168/X VPWR VGND sg13cmos5l_dfrbpq_1
X_3061_ _3061_/Q _3061_/CLK _3061_/D fanout175/X VPWR VGND sg13cmos5l_dfrbpq_1
XFILLER_48_594 VPWR VGND sg13cmos5l_decap_8
XFILLER_35_211 VPWR VGND sg13cmos5l_decap_4
X_2012_ _2013_/B _2101_/A _1966_/B _2169_/B _2011_/Y VPWR VGND sg13cmos5l_a22oi_1
XFILLER_36_789 VPWR VGND sg13cmos5l_decap_8
XFILLER_35_244 VPWR VGND sg13cmos5l_decap_8
XFILLER_17_970 VPWR VGND sg13cmos5l_decap_8
X_2914_ _2914_/Y _2914_/A _2914_/B _2914_/C _2914_/D VPWR VGND sg13cmos5l_nand4_1
XFILLER_32_962 VPWR VGND sg13cmos5l_decap_8
X_2845_ _2847_/B _2845_/A _2845_/B VPWR VGND sg13cmos5l_and2_1
X_2776_ _2776_/Y _2778_/A _2776_/B VPWR VGND sg13cmos5l_nand2_1
XFILLER_8_690 VPWR VGND sg13cmos5l_decap_8
X_1727_ _1728_/A _1644_/A _1726_/Y _1733_/B VPWR VGND sg13cmos5l_o21ai_1
X_1658_ _1746_/A _1658_/A _1658_/B VPWR VGND sg13cmos5l_nor2_1
X_1589_ _1646_/D _1570_/B _1570_/C _1584_/A VPWR VGND sg13cmos5l_a21o_1
XFILLER_15_907 VPWR VGND sg13cmos5l_decap_8
XFILLER_26_233 VPWR VGND sg13cmos5l_decap_8
XFILLER_27_756 VPWR VGND sg13cmos5l_decap_4
XFILLER_42_726 VPWR VGND sg13cmos5l_decap_8
XFILLER_26_266 VPWR VGND sg13cmos5l_decap_8
XFILLER_27_789 VPWR VGND sg13cmos5l_decap_8
XFILLER_14_439 VPWR VGND sg13cmos5l_decap_4
XFILLER_10_623 VPWR VGND sg13cmos5l_fill_1
XFILLER_23_995 VPWR VGND sg13cmos5l_decap_8
XFILLER_10_667 VPWR VGND sg13cmos5l_decap_8
XFILLER_5_115 VPWR VGND sg13cmos5l_fill_2
XFILLER_2_866 VPWR VGND sg13cmos5l_decap_8
XFILLER_49_303 VPWR VGND sg13cmos5l_decap_8
XFILLER_1_354 VPWR VGND sg13cmos5l_fill_1
XFILLER_1_398 VPWR VGND sg13cmos5l_decap_8
XFILLER_40_1010 VPWR VGND sg13cmos5l_decap_8
XFILLER_18_723 VPWR VGND sg13cmos5l_decap_4
XFILLER_18_789 VPWR VGND sg13cmos5l_decap_8
XFILLER_14_940 VPWR VGND sg13cmos5l_decap_8
XFILLER_32_225 VPWR VGND sg13cmos5l_fill_2
XFILLER_13_461 VPWR VGND sg13cmos5l_fill_2
XFILLER_9_432 VPWR VGND sg13cmos5l_decap_8
XFILLER_13_472 VPWR VGND sg13cmos5l_fill_1
XFILLER_13_483 VPWR VGND sg13cmos5l_fill_1
XFILLER_13_494 VPWR VGND sg13cmos5l_decap_8
X_2630_ _2630_/Y _2465_/B _2630_/B VPWR VGND sg13cmos5l_nand2b_1
X_2561_ _2565_/A _3008_/Q _3009_/Q VPWR VGND sg13cmos5l_xor2_1
X_2492_ _2510_/C _2515_/A _2997_/Q VPWR VGND sg13cmos5l_nand2_1
XFILLER_5_671 VPWR VGND sg13cmos5l_decap_8
X_1512_ _2885_/A _2883_/A VPWR VGND sg13cmos5l_inv_1
X_3113_ _3113_/Q _3117_/CLK _3113_/D fanout149/X VPWR VGND sg13cmos5l_dfrbpq_1
XFILLER_49_881 VPWR VGND sg13cmos5l_decap_8
X_3044_ _3044_/Q clkload7/A _3044_/D fanout174/X VPWR VGND sg13cmos5l_dfrbpq_1
XFILLER_23_203 VPWR VGND sg13cmos5l_decap_8
XFILLER_23_236 VPWR VGND sg13cmos5l_fill_1
XFILLER_24_759 VPWR VGND sg13cmos5l_fill_1
XFILLER_11_409 VPWR VGND sg13cmos5l_fill_1
XFILLER_17_1012 VPWR VGND sg13cmos5l_decap_8
X_2828_ _3054_/D _2843_/A _2828_/B _2830_/B VPWR VGND sg13cmos5l_nor3_1
XFILLER_20_987 VPWR VGND sg13cmos5l_decap_8
X_2759_ _2759_/Y _2759_/A _2759_/B VPWR VGND sg13cmos5l_nand2_1
XFILLER_3_619 VPWR VGND sg13cmos5l_decap_8
XFILLER_2_129 VPWR VGND sg13cmos5l_decap_8
XFILLER_48_14 VPWR VGND sg13cmos5l_fill_2
XFILLER_47_807 VPWR VGND sg13cmos5l_decap_8
XFILLER_27_531 VPWR VGND sg13cmos5l_fill_1
XFILLER_42_501 VPWR VGND sg13cmos5l_decap_4
XFILLER_14_247 VPWR VGND sg13cmos5l_decap_8
XFILLER_15_748 VPWR VGND sg13cmos5l_decap_8
XFILLER_27_597 VPWR VGND sg13cmos5l_fill_1
Xfanout40 _2592_/S _2543_/Y VPWR VGND sg13cmos5l_buf_1
XFILLER_42_578 VPWR VGND sg13cmos5l_decap_8
Xfanout73 _2113_/A _2196_/A VPWR VGND sg13cmos5l_buf_1
Xfanout51 _2308_/B _1848_/Y VPWR VGND sg13cmos5l_buf_1
Xfanout62 _2037_/A _1842_/Y VPWR VGND sg13cmos5l_buf_1
XFILLER_11_943 VPWR VGND sg13cmos5l_decap_8
Xfanout95 _2153_/A _2317_/A VPWR VGND sg13cmos5l_buf_1
Xfanout84 _2485_/A2 _2444_/X VPWR VGND sg13cmos5l_buf_1
XFILLER_7_958 VPWR VGND sg13cmos5l_decap_8
XFILLER_6_435 VPWR VGND sg13cmos5l_decap_4
XFILLER_6_479 VPWR VGND sg13cmos5l_decap_8
XFILLER_2_663 VPWR VGND sg13cmos5l_decap_8
XFILLER_49_111 VPWR VGND sg13cmos5l_decap_8
XFILLER_49_155 VPWR VGND sg13cmos5l_fill_1
XFILLER_46_862 VPWR VGND sg13cmos5l_decap_8
Xclkbuf_5_24__f_clk _3085_/CLK clkbuf_4_12_0_clk/X VPWR VGND sg13cmos5l_buf_8
XFILLER_21_718 VPWR VGND sg13cmos5l_decap_8
XFILLER_14_770 VPWR VGND sg13cmos5l_fill_1
X_1992_ _1993_/C _2231_/A _2036_/B _2273_/A VPWR VGND sg13cmos5l_a21oi_1
XFILLER_9_240 VPWR VGND sg13cmos5l_fill_1
X_2613_ _3021_/D _2615_/A _2613_/B VPWR VGND sg13cmos5l_nor2_1
X_2544_ _2990_/D _2592_/S _2568_/A _2544_/S VPWR VGND sg13cmos5l_mux2_1
XFILLER_6_991 VPWR VGND sg13cmos5l_decap_8
XFILLER_48_0 VPWR VGND sg13cmos5l_decap_8
X_2475_ _2475_/Y _2472_/B _2474_/Y _2472_/Y VPWR VGND sg13cmos5l_a21oi_1
XFILLER_29_818 VPWR VGND sg13cmos5l_decap_8
XFILLER_28_317 VPWR VGND sg13cmos5l_fill_2
XFILLER_37_851 VPWR VGND sg13cmos5l_decap_4
XFILLER_43_309 VPWR VGND sg13cmos5l_decap_4
X_3027_ _3027_/Q _3123_/CLK _3027_/D fanout152/X VPWR VGND sg13cmos5l_dfrbpq_1
XFILLER_12_707 VPWR VGND sg13cmos5l_decap_8
XFILLER_24_556 VPWR VGND sg13cmos5l_decap_8
Xclkload4 clkload4/Y clkload4/A VPWR VGND sg13cmos5l_inv_1
XFILLER_20_762 VPWR VGND sg13cmos5l_decap_8
XFILLER_47_637 VPWR VGND sg13cmos5l_decap_8
XFILLER_46_103 VPWR VGND sg13cmos5l_decap_8
XFILLER_28_895 VPWR VGND sg13cmos5l_decap_8
XFILLER_27_383 VPWR VGND sg13cmos5l_decap_8
XFILLER_15_567 VPWR VGND sg13cmos5l_decap_4
XFILLER_30_526 VPWR VGND sg13cmos5l_fill_2
XFILLER_7_755 VPWR VGND sg13cmos5l_decap_8
XFILLER_6_232 VPWR VGND sg13cmos5l_fill_2
XFILLER_40_81 VPWR VGND sg13cmos5l_decap_8
XFILLER_6_276 VPWR VGND sg13cmos5l_decap_8
XFILLER_41_7 VPWR VGND sg13cmos5l_decap_8
XFILLER_3_994 VPWR VGND sg13cmos5l_decap_8
XFILLER_2_460 VPWR VGND sg13cmos5l_decap_8
X_2260_ _2260_/Y _1917_/B _1970_/Y _2259_/X _1899_/Y _1839_/X VPWR VGND sg13cmos5l_a221oi_1
XFILLER_38_637 VPWR VGND sg13cmos5l_decap_8
XFILLER_38_615 VPWR VGND sg13cmos5l_decap_8
X_2191_ _2191_/Y _2178_/X _2190_/Y _1982_/A VPWR VGND sg13cmos5l_a21oi_1
XFILLER_18_350 VPWR VGND sg13cmos5l_decap_8
XFILLER_46_681 VPWR VGND sg13cmos5l_decap_8
XFILLER_19_895 VPWR VGND sg13cmos5l_decap_8
XFILLER_45_191 VPWR VGND sg13cmos5l_decap_8
XFILLER_33_364 VPWR VGND sg13cmos5l_decap_8
X_1975_ _2294_/C _2186_/B _2148_/B VPWR VGND sg13cmos5l_or2_1
XFILLER_21_559 VPWR VGND sg13cmos5l_decap_8
XFILLER_20_18 VPWR VGND sg13cmos5l_decap_8
X_2527_ _2527_/X _1523_/A _2529_/A _2526_/Y VPWR VGND sg13cmos5l_a21o_1
X_2458_ _2635_/B _2634_/S _3029_/Q VPWR VGND sg13cmos5l_nor2b_1
XFILLER_29_49 VPWR VGND sg13cmos5l_decap_8
X_2389_ _2391_/B _2390_/A _2390_/B VPWR VGND sg13cmos5l_nor2_1
XFILLER_28_147 VPWR VGND sg13cmos5l_decap_8
XFILLER_29_648 VPWR VGND sg13cmos5l_decap_8
XFILLER_44_618 VPWR VGND sg13cmos5l_decap_8
XFILLER_43_106 VPWR VGND sg13cmos5l_decap_8
XFILLER_37_681 VPWR VGND sg13cmos5l_decap_8
XFILLER_25_843 VPWR VGND sg13cmos5l_fill_2
XFILLER_25_865 VPWR VGND sg13cmos5l_decap_8
XFILLER_12_537 VPWR VGND sg13cmos5l_decap_4
XFILLER_25_898 VPWR VGND sg13cmos5l_fill_1
XFILLER_4_769 VPWR VGND sg13cmos5l_decap_8
XFILLER_3_257 VPWR VGND sg13cmos5l_decap_8
XFILLER_0_964 VPWR VGND sg13cmos5l_decap_8
XFILLER_48_935 VPWR VGND sg13cmos5l_decap_8
XFILLER_19_103 VPWR VGND sg13cmos5l_decap_8
XFILLER_35_629 VPWR VGND sg13cmos5l_decap_8
XFILLER_19_169 VPWR VGND sg13cmos5l_fill_2
XFILLER_28_681 VPWR VGND sg13cmos5l_decap_8
XFILLER_28_692 VPWR VGND sg13cmos5l_fill_1
XFILLER_43_684 VPWR VGND sg13cmos5l_decap_8
XFILLER_42_161 VPWR VGND sg13cmos5l_decap_4
XFILLER_15_375 VPWR VGND sg13cmos5l_decap_8
XFILLER_42_183 VPWR VGND sg13cmos5l_fill_2
XFILLER_15_397 VPWR VGND sg13cmos5l_decap_8
XFILLER_31_846 VPWR VGND sg13cmos5l_decap_8
X_1760_ _1760_/Y _2332_/A _1755_/Y _1759_/Y _2612_/A VPWR VGND sg13cmos5l_a22oi_1
X_1691_ _1691_/Y _2362_/A _1690_/Y _1696_/A VPWR VGND sg13cmos5l_a21oi_1
XFILLER_3_791 VPWR VGND sg13cmos5l_decap_8
X_2312_ _2312_/Y _2031_/C _2311_/Y _2153_/X VPWR VGND sg13cmos5l_a21oi_1
X_2243_ _2249_/A _2301_/B _2242_/Y _2241_/Y VPWR VGND sg13cmos5l_o21ai_1
XFILLER_39_968 VPWR VGND sg13cmos5l_decap_8
XFILLER_38_434 VPWR VGND sg13cmos5l_decap_8
X_2174_ _2175_/C _2297_/C _2023_/A _2294_/A VPWR VGND sg13cmos5l_a21oi_1
XFILLER_19_681 VPWR VGND sg13cmos5l_decap_8
XFILLER_19_692 VPWR VGND sg13cmos5l_fill_1
XFILLER_18_180 VPWR VGND sg13cmos5l_decap_8
XFILLER_34_640 VPWR VGND sg13cmos5l_decap_8
XFILLER_21_312 VPWR VGND sg13cmos5l_decap_8
XFILLER_33_150 VPWR VGND sg13cmos5l_fill_1
XFILLER_21_323 VPWR VGND sg13cmos5l_decap_8
XFILLER_22_846 VPWR VGND sg13cmos5l_fill_2
XFILLER_22_868 VPWR VGND sg13cmos5l_decap_8
X_1958_ _1958_/X _2118_/B _1966_/B _1957_/Y VPWR VGND sg13cmos5l_a21o_1
XFILLER_30_890 VPWR VGND sg13cmos5l_decap_8
X_1889_ _1889_/Y _1889_/A _2151_/B VPWR VGND sg13cmos5l_nand2_1
XFILLER_29_423 VPWR VGND sg13cmos5l_fill_1
XFILLER_45_905 VPWR VGND sg13cmos5l_decap_8
XFILLER_29_456 VPWR VGND sg13cmos5l_decap_4
XFILLER_44_415 VPWR VGND sg13cmos5l_fill_1
XFILLER_13_835 VPWR VGND sg13cmos5l_decap_4
XFILLER_24_172 VPWR VGND sg13cmos5l_decap_8
XFILLER_25_673 VPWR VGND sg13cmos5l_decap_8
XFILLER_31_109 VPWR VGND sg13cmos5l_decap_8
XFILLER_12_345 VPWR VGND sg13cmos5l_decap_8
XFILLER_8_316 VPWR VGND sg13cmos5l_fill_1
XFILLER_9_828 VPWR VGND sg13cmos5l_decap_8
XFILLER_4_533 VPWR VGND sg13cmos5l_fill_2
XFILLER_4_522 VPWR VGND sg13cmos5l_decap_8
XFILLER_4_555 VPWR VGND sg13cmos5l_fill_2
XFILLER_48_710 VPWR VGND sg13cmos5l_decap_4
XFILLER_0_761 VPWR VGND sg13cmos5l_decap_8
XFILLER_48_754 VPWR VGND sg13cmos5l_decap_4
XFILLER_47_220 VPWR VGND sg13cmos5l_decap_8
XFILLER_11_8 VPWR VGND sg13cmos5l_fill_1
XFILLER_35_426 VPWR VGND sg13cmos5l_decap_8
XFILLER_46_80 VPWR VGND sg13cmos5l_fill_2
XFILLER_44_960 VPWR VGND sg13cmos5l_decap_8
X_2930_ _2939_/A _2442_/A _2934_/C _3041_/Q VPWR VGND sg13cmos5l_o21ai_1
XFILLER_16_662 VPWR VGND sg13cmos5l_decap_8
XFILLER_15_183 VPWR VGND sg13cmos5l_decap_8
X_2861_ _2861_/Y _2886_/A1 _2860_/Y _2859_/Y VPWR VGND sg13cmos5l_o21ai_1
XFILLER_30_131 VPWR VGND sg13cmos5l_fill_1
X_2792_ _2802_/B _3033_/Q _2813_/A VPWR VGND sg13cmos5l_xnor2_1
XFILLER_30_175 VPWR VGND sg13cmos5l_decap_4
X_1812_ _1813_/C _1812_/A _1812_/B _1812_/C _1812_/D VPWR VGND sg13cmos5l_nand4_1
XFILLER_8_872 VPWR VGND sg13cmos5l_decap_8
XFILLER_7_41 VPWR VGND sg13cmos5l_fill_1
X_1743_ _1743_/X _1725_/Y _1742_/Y _1710_/Y VPWR VGND sg13cmos5l_a21o_1
Xhold305 _2849_/A _2847_/Y VPWR VGND sg13cmos5l_dlygate4sd3_1
XFILLER_7_85 VPWR VGND sg13cmos5l_decap_4
Xhold316 _2387_/A _3119_/Q VPWR VGND sg13cmos5l_dlygate4sd3_1
X_1674_ _1674_/Y _1722_/C _1733_/A _1673_/Y _1817_/A VPWR VGND sg13cmos5l_a22oi_1
Xhold338 _2813_/A _3049_/Q VPWR VGND sg13cmos5l_dlygate4sd3_1
Xhold327 _3057_/D _2837_/Y VPWR VGND sg13cmos5l_dlygate4sd3_1
Xhold349 _1501_/A _3062_/Q VPWR VGND sg13cmos5l_dlygate4sd3_1
X_2226_ _2226_/Y _2253_/A _2226_/B _2226_/C VPWR VGND sg13cmos5l_nor3_1
XFILLER_39_776 VPWR VGND sg13cmos5l_fill_1
XFILLER_38_264 VPWR VGND sg13cmos5l_decap_8
XFILLER_26_404 VPWR VGND sg13cmos5l_decap_8
XFILLER_27_927 VPWR VGND sg13cmos5l_decap_8
X_2157_ _2158_/C _2404_/A _2157_/B _2157_/C VPWR VGND sg13cmos5l_nand3_1
XFILLER_26_39 VPWR VGND sg13cmos5l_decap_8
X_2088_ _2089_/D _2088_/A _2281_/A _2158_/B VPWR VGND sg13cmos5l_nand3_1
XFILLER_35_971 VPWR VGND sg13cmos5l_decap_8
XFILLER_22_610 VPWR VGND sg13cmos5l_decap_8
XFILLER_34_492 VPWR VGND sg13cmos5l_decap_8
XFILLER_6_809 VPWR VGND sg13cmos5l_decap_8
XFILLER_10_838 VPWR VGND sg13cmos5l_decap_8
XFILLER_21_175 VPWR VGND sg13cmos5l_fill_1
XFILLER_27_1025 VPWR VGND sg13cmos5l_decap_4
XFILLER_49_529 VPWR VGND sg13cmos5l_decap_8
XFILLER_29_220 VPWR VGND sg13cmos5l_decap_8
Xclkbuf_5_5__f_clk clkload1/A clkbuf_4_2_0_clk/X VPWR VGND sg13cmos5l_buf_8
XFILLER_44_201 VPWR VGND sg13cmos5l_fill_1
XFILLER_29_297 VPWR VGND sg13cmos5l_decap_8
XFILLER_45_779 VPWR VGND sg13cmos5l_fill_1
XFILLER_26_993 VPWR VGND sg13cmos5l_decap_8
XFILLER_32_429 VPWR VGND sg13cmos5l_decap_8
XFILLER_41_952 VPWR VGND sg13cmos5l_decap_8
XFILLER_40_451 VPWR VGND sg13cmos5l_fill_1
XFILLER_40_440 VPWR VGND sg13cmos5l_decap_8
XFILLER_9_603 VPWR VGND sg13cmos5l_decap_8
XFILLER_13_665 VPWR VGND sg13cmos5l_decap_8
XFILLER_9_647 VPWR VGND sg13cmos5l_decap_8
XFILLER_13_698 VPWR VGND sg13cmos5l_decap_8
XFILLER_8_168 VPWR VGND sg13cmos5l_decap_8
XFILLER_5_853 VPWR VGND sg13cmos5l_decap_8
X_3060_ _3060_/Q _3060_/CLK _3060_/D fanout175/X VPWR VGND sg13cmos5l_dfrbpq_1
X_2011_ _2011_/Y _2244_/C _2186_/C _2598_/A _2011_/D VPWR VGND sg13cmos5l_nand4_1
XFILLER_35_201 VPWR VGND sg13cmos5l_fill_1
XFILLER_36_768 VPWR VGND sg13cmos5l_decap_8
XFILLER_32_941 VPWR VGND sg13cmos5l_decap_8
X_2913_ _2913_/Y _2913_/A _2913_/B VPWR VGND sg13cmos5l_nor2_1
X_2844_ _2846_/B _2845_/A _2845_/B VPWR VGND sg13cmos5l_nor2_1
X_2775_ _3044_/D _2771_/A _2754_/B _2774_/Y VPWR VGND sg13cmos5l_a21o_1
X_1726_ _1726_/Y _1726_/A _1726_/B _1726_/C _1726_/D VPWR VGND sg13cmos5l_nor4_1
X_1657_ _1658_/B _1831_/C _1661_/B VPWR VGND sg13cmos5l_nor2_1
X_1588_ _1588_/Y _1646_/B _1646_/C _1816_/A VPWR VGND sg13cmos5l_o21ai_1
XFILLER_37_27 VPWR VGND sg13cmos5l_fill_2
XFILLER_37_16 VPWR VGND sg13cmos5l_decap_8
XFILLER_39_573 VPWR VGND sg13cmos5l_decap_8
XFILLER_2_1027 VPWR VGND sg13cmos5l_fill_2
X_2209_ _2210_/B _2205_/A _2257_/B _2208_/Y VPWR VGND sg13cmos5l_o21ai_1
XFILLER_26_212 VPWR VGND sg13cmos5l_decap_8
XFILLER_41_259 VPWR VGND sg13cmos5l_decap_8
XFILLER_23_974 VPWR VGND sg13cmos5l_decap_8
XFILLER_10_646 VPWR VGND sg13cmos5l_decap_8
XFILLER_2_845 VPWR VGND sg13cmos5l_decap_8
XFILLER_1_322 VPWR VGND sg13cmos5l_decap_4
XFILLER_1_366 VPWR VGND sg13cmos5l_decap_8
XFILLER_49_359 VPWR VGND sg13cmos5l_decap_8
XFILLER_17_245 VPWR VGND sg13cmos5l_decap_8
XFILLER_18_768 VPWR VGND sg13cmos5l_decap_8
XFILLER_27_71 VPWR VGND sg13cmos5l_decap_4
XFILLER_45_598 VPWR VGND sg13cmos5l_decap_8
XFILLER_17_289 VPWR VGND sg13cmos5l_decap_8
XFILLER_13_451 VPWR VGND sg13cmos5l_decap_4
XFILLER_43_92 VPWR VGND sg13cmos5l_decap_8
XFILLER_40_270 VPWR VGND sg13cmos5l_decap_8
XFILLER_14_996 VPWR VGND sg13cmos5l_decap_8
X_2560_ _2567_/A _3012_/Q _2560_/B VPWR VGND sg13cmos5l_xnor2_1
XFILLER_5_650 VPWR VGND sg13cmos5l_decap_8
X_2491_ _2491_/Y _2473_/A _2490_/B hold297/X VPWR VGND sg13cmos5l_a21oi_1
X_1511_ _2869_/A _2867_/A VPWR VGND sg13cmos5l_inv_1
XFILLER_4_171 VPWR VGND sg13cmos5l_decap_8
XFILLER_49_860 VPWR VGND sg13cmos5l_decap_8
X_3112_ _3112_/Q _3117_/CLK _3112_/D fanout150/X VPWR VGND sg13cmos5l_dfrbpq_1
X_3043_ _3043_/Q clkload7/A _3043_/D fanout174/X VPWR VGND sg13cmos5l_dfrbpq_1
XFILLER_48_392 VPWR VGND sg13cmos5l_decap_8
XFILLER_36_576 VPWR VGND sg13cmos5l_decap_8
XFILLER_23_215 VPWR VGND sg13cmos5l_decap_8
XFILLER_24_738 VPWR VGND sg13cmos5l_decap_8
XFILLER_23_18 VPWR VGND sg13cmos5l_decap_4
XFILLER_20_966 VPWR VGND sg13cmos5l_decap_8
X_2827_ _2830_/B _2827_/A _2827_/B VPWR VGND sg13cmos5l_and2_1
X_2758_ _2759_/B _3040_/Q _3041_/Q _2749_/B VPWR VGND sg13cmos5l_o21ai_1
X_1709_ _1710_/D _1732_/C _1709_/B _1709_/C VPWR VGND sg13cmos5l_nor3_1
X_2689_ _2692_/A _2948_/A _2689_/B VPWR VGND sg13cmos5l_xnor2_1
XFILLER_24_1028 VPWR VGND sg13cmos5l_fill_1
XFILLER_14_204 VPWR VGND sg13cmos5l_fill_2
XFILLER_15_727 VPWR VGND sg13cmos5l_decap_8
XFILLER_14_226 VPWR VGND sg13cmos5l_decap_8
Xfanout30 _2529_/A _2533_/B VPWR VGND sg13cmos5l_buf_1
Xfanout41 _2589_/S _2543_/Y VPWR VGND sg13cmos5l_buf_1
Xfanout63 _2240_/A _1943_/A VPWR VGND sg13cmos5l_buf_1
XFILLER_10_410 VPWR VGND sg13cmos5l_fill_1
XFILLER_11_922 VPWR VGND sg13cmos5l_decap_8
Xfanout52 _2244_/C _2246_/C VPWR VGND sg13cmos5l_buf_1
Xfanout74 _2196_/A _2253_/A VPWR VGND sg13cmos5l_buf_1
XFILLER_23_793 VPWR VGND sg13cmos5l_fill_1
Xfanout85 _1845_/B _1834_/Y VPWR VGND sg13cmos5l_buf_1
Xfanout96 _2317_/A _1495_/Y VPWR VGND sg13cmos5l_buf_1
XFILLER_7_937 VPWR VGND sg13cmos5l_decap_8
XFILLER_6_414 VPWR VGND sg13cmos5l_fill_2
XFILLER_6_403 VPWR VGND sg13cmos5l_decap_8
XFILLER_11_999 VPWR VGND sg13cmos5l_decap_8
XFILLER_6_469 VPWR VGND sg13cmos5l_decap_4
XFILLER_10_498 VPWR VGND sg13cmos5l_decap_8
XFILLER_2_642 VPWR VGND sg13cmos5l_decap_8
XFILLER_49_101 VPWR VGND sg13cmos5l_fill_1
XFILLER_18_521 VPWR VGND sg13cmos5l_decap_8
XFILLER_45_362 VPWR VGND sg13cmos5l_decap_8
XFILLER_45_340 VPWR VGND sg13cmos5l_decap_8
XFILLER_45_384 VPWR VGND sg13cmos5l_decap_8
XFILLER_33_557 VPWR VGND sg13cmos5l_decap_8
XFILLER_14_793 VPWR VGND sg13cmos5l_decap_8
X_1991_ _1993_/B _2054_/B _2251_/B _2056_/B VPWR VGND sg13cmos5l_nand3_1
XFILLER_9_274 VPWR VGND sg13cmos5l_decap_8
X_2612_ _2613_/B _2612_/A _2612_/B VPWR VGND sg13cmos5l_xnor2_1
X_2543_ _2543_/Y _2568_/A _2543_/B VPWR VGND sg13cmos5l_nor2_1
XFILLER_6_970 VPWR VGND sg13cmos5l_decap_8
XFILLER_47_1028 VPWR VGND sg13cmos5l_fill_1
X_2474_ _2474_/Y _2976_/Q _2485_/A2 _2446_/B _2473_/Y VPWR VGND sg13cmos5l_a22oi_1
XFILLER_37_863 VPWR VGND sg13cmos5l_decap_4
X_3026_ _3026_/Q _3123_/CLK _3026_/D fanout152/X VPWR VGND sg13cmos5l_dfrbpq_1
XFILLER_36_373 VPWR VGND sg13cmos5l_fill_1
XFILLER_24_513 VPWR VGND sg13cmos5l_decap_8
XFILLER_24_524 VPWR VGND sg13cmos5l_fill_1
XFILLER_11_229 VPWR VGND sg13cmos5l_decap_8
Xclkload5 clkload5/Y clkload5/A VPWR VGND sg13cmos5l_inv_1
Xclkbuf_5_30__f_clk _3061_/CLK clkbuf_4_15_0_clk/X VPWR VGND sg13cmos5l_buf_8
XFILLER_3_439 VPWR VGND sg13cmos5l_decap_8
XFILLER_47_627 VPWR VGND sg13cmos5l_fill_1
XFILLER_47_616 VPWR VGND sg13cmos5l_decap_8
XFILLER_46_159 VPWR VGND sg13cmos5l_decap_8
XFILLER_27_362 VPWR VGND sg13cmos5l_decap_8
XFILLER_28_874 VPWR VGND sg13cmos5l_decap_8
XFILLER_43_833 VPWR VGND sg13cmos5l_fill_2
XFILLER_43_822 VPWR VGND sg13cmos5l_fill_1
XFILLER_15_524 VPWR VGND sg13cmos5l_fill_1
XFILLER_42_332 VPWR VGND sg13cmos5l_decap_4
XFILLER_15_546 VPWR VGND sg13cmos5l_decap_8
XFILLER_43_899 VPWR VGND sg13cmos5l_decap_8
XFILLER_42_365 VPWR VGND sg13cmos5l_decap_8
XFILLER_30_549 VPWR VGND sg13cmos5l_decap_8
XFILLER_7_734 VPWR VGND sg13cmos5l_decap_8
XFILLER_6_200 VPWR VGND sg13cmos5l_fill_2
XFILLER_10_251 VPWR VGND sg13cmos5l_decap_8
XFILLER_11_774 VPWR VGND sg13cmos5l_decap_8
XFILLER_11_785 VPWR VGND sg13cmos5l_fill_2
XFILLER_40_60 VPWR VGND sg13cmos5l_decap_8
XFILLER_6_255 VPWR VGND sg13cmos5l_decap_4
XFILLER_3_973 VPWR VGND sg13cmos5l_decap_8
XFILLER_2_483 VPWR VGND sg13cmos5l_fill_1
XFILLER_34_7 VPWR VGND sg13cmos5l_decap_8
X_2190_ _2190_/Y _2332_/B _2244_/C _2190_/C VPWR VGND sg13cmos5l_nand3_1
XFILLER_37_137 VPWR VGND sg13cmos5l_decap_4
XFILLER_19_830 VPWR VGND sg13cmos5l_fill_2
XFILLER_46_660 VPWR VGND sg13cmos5l_decap_8
XFILLER_19_874 VPWR VGND sg13cmos5l_decap_8
XFILLER_45_170 VPWR VGND sg13cmos5l_decap_8
XFILLER_33_343 VPWR VGND sg13cmos5l_decap_8
XFILLER_21_538 VPWR VGND sg13cmos5l_decap_8
X_1974_ _1979_/B _2251_/A _2318_/A _1974_/C VPWR VGND sg13cmos5l_or3_1
X_2526_ _2526_/Y _2963_/C _2515_/D VPWR VGND sg13cmos5l_nor2b_1
X_2457_ _2457_/Y _2480_/B _2455_/Y _2456_/Y VPWR VGND sg13cmos5l_a21oi_1
X_2388_ _2388_/Y _2393_/A _2390_/B _2388_/C VPWR VGND sg13cmos5l_nor3_1
X_3009_ _3009_/Q _3009_/CLK _3009_/D fanout158/X VPWR VGND sg13cmos5l_dfrbpq_1
XFILLER_36_170 VPWR VGND sg13cmos5l_decap_8
XFILLER_24_343 VPWR VGND sg13cmos5l_decap_4
XFILLER_40_836 VPWR VGND sg13cmos5l_fill_2
XFILLER_12_505 VPWR VGND sg13cmos5l_fill_2
XFILLER_4_748 VPWR VGND sg13cmos5l_decap_8
XFILLER_3_225 VPWR VGND sg13cmos5l_decap_8
XFILLER_0_943 VPWR VGND sg13cmos5l_decap_8
XFILLER_48_914 VPWR VGND sg13cmos5l_decap_8
XFILLER_19_83 VPWR VGND sg13cmos5l_fill_1
XFILLER_47_457 VPWR VGND sg13cmos5l_fill_2
XFILLER_15_310 VPWR VGND sg13cmos5l_decap_8
XFILLER_16_844 VPWR VGND sg13cmos5l_fill_1
XFILLER_43_663 VPWR VGND sg13cmos5l_decap_8
XFILLER_15_321 VPWR VGND sg13cmos5l_fill_1
XFILLER_27_192 VPWR VGND sg13cmos5l_fill_2
XFILLER_16_888 VPWR VGND sg13cmos5l_decap_8
X_1690_ _1690_/Y _1693_/A _1690_/B VPWR VGND sg13cmos5l_nand2_1
XFILLER_44_1009 VPWR VGND sg13cmos5l_decap_8
XFILLER_3_770 VPWR VGND sg13cmos5l_decap_8
X_2311_ _2311_/Y _2311_/A _2311_/B VPWR VGND sg13cmos5l_nand2_1
X_2242_ _2242_/Y _2242_/A _2598_/A VPWR VGND sg13cmos5l_nor2_1
XFILLER_39_947 VPWR VGND sg13cmos5l_decap_8
X_2173_ _2173_/Y _2173_/A _2229_/A VPWR VGND sg13cmos5l_nor2b_1
XFILLER_19_660 VPWR VGND sg13cmos5l_decap_8
XFILLER_18_170 VPWR VGND sg13cmos5l_decap_4
XFILLER_25_107 VPWR VGND sg13cmos5l_fill_1
XFILLER_22_814 VPWR VGND sg13cmos5l_decap_4
XFILLER_22_825 VPWR VGND sg13cmos5l_decap_8
XFILLER_33_162 VPWR VGND sg13cmos5l_decap_4
XFILLER_34_696 VPWR VGND sg13cmos5l_decap_8
XFILLER_33_173 VPWR VGND sg13cmos5l_fill_1
XFILLER_21_379 VPWR VGND sg13cmos5l_decap_8
X_1957_ _1957_/Y _1907_/A _2221_/A _1943_/A VPWR VGND sg13cmos5l_o21ai_1
X_1888_ _1913_/B _2246_/C _1888_/B _2308_/D VPWR VGND sg13cmos5l_nand3_1
X_2509_ _2512_/D _2509_/A _2509_/B _2509_/C VPWR VGND sg13cmos5l_nand3_1
XFILLER_0_228 VPWR VGND sg13cmos5l_decap_8
XFILLER_5_1014 VPWR VGND sg13cmos5l_decap_8
XFILLER_29_402 VPWR VGND sg13cmos5l_decap_8
XFILLER_16_107 VPWR VGND sg13cmos5l_fill_1
XFILLER_25_652 VPWR VGND sg13cmos5l_decap_8
XFILLER_13_814 VPWR VGND sg13cmos5l_decap_8
XFILLER_24_151 VPWR VGND sg13cmos5l_decap_8
XFILLER_9_807 VPWR VGND sg13cmos5l_decap_8
XFILLER_12_324 VPWR VGND sg13cmos5l_decap_8
XFILLER_13_847 VPWR VGND sg13cmos5l_decap_8
XFILLER_13_858 VPWR VGND sg13cmos5l_fill_2
XFILLER_40_699 VPWR VGND sg13cmos5l_decap_8
XFILLER_21_880 VPWR VGND sg13cmos5l_fill_1
XFILLER_21_51 VPWR VGND sg13cmos5l_decap_4
XFILLER_21_73 VPWR VGND sg13cmos5l_fill_2
XFILLER_0_740 VPWR VGND sg13cmos5l_decap_8
XFILLER_47_254 VPWR VGND sg13cmos5l_decap_8
XFILLER_35_405 VPWR VGND sg13cmos5l_decap_8
XFILLER_15_162 VPWR VGND sg13cmos5l_decap_8
XFILLER_31_611 VPWR VGND sg13cmos5l_fill_1
XFILLER_43_482 VPWR VGND sg13cmos5l_fill_1
XFILLER_15_173 VPWR VGND sg13cmos5l_fill_1
X_2860_ _2860_/Y _3064_/Q _2860_/B VPWR VGND sg13cmos5l_xnor2_1
XFILLER_31_633 VPWR VGND sg13cmos5l_decap_8
XFILLER_30_154 VPWR VGND sg13cmos5l_decap_8
X_1811_ _1813_/B _3069_/Q _1786_/B _1805_/Y VPWR VGND sg13cmos5l_o21ai_1
X_2791_ _2803_/B _3031_/Q _3047_/Q VPWR VGND sg13cmos5l_xnor2_1
XFILLER_12_891 VPWR VGND sg13cmos5l_decap_8
XFILLER_8_851 VPWR VGND sg13cmos5l_decap_8
X_1742_ _1742_/Y _1740_/Y _1741_/Y _1488_/Y VPWR VGND sg13cmos5l_a21oi_1
Xhold306 _3061_/D _2849_/Y VPWR VGND sg13cmos5l_dlygate4sd3_1
Xhold317 _2388_/C _2387_/Y VPWR VGND sg13cmos5l_dlygate4sd3_1
X_1673_ _1673_/Y _1722_/A _1720_/B _1732_/B VPWR VGND sg13cmos5l_o21ai_1
Xhold339 _2814_/B _2812_/Y VPWR VGND sg13cmos5l_dlygate4sd3_1
Xhold328 _2842_/A _3059_/Q VPWR VGND sg13cmos5l_dlygate4sd3_1
XFILLER_39_744 VPWR VGND sg13cmos5l_fill_2
X_2225_ _2284_/B _3107_/Q _2225_/B _2225_/C VPWR VGND sg13cmos5l_nand3_1
XFILLER_39_766 VPWR VGND sg13cmos5l_fill_2
XFILLER_27_906 VPWR VGND sg13cmos5l_decap_8
X_2156_ _2157_/C _2323_/A _2156_/B _2156_/C _2156_/D VPWR VGND sg13cmos5l_nand4_1
XFILLER_26_18 VPWR VGND sg13cmos5l_decap_8
XFILLER_35_950 VPWR VGND sg13cmos5l_decap_8
X_2087_ _2158_/B _2210_/A _2290_/C VPWR VGND sg13cmos5l_nand2_1
XFILLER_34_471 VPWR VGND sg13cmos5l_decap_8
X_2989_ _2989_/Q clkload3/A _2989_/D fanout162/X VPWR VGND sg13cmos5l_dfrbpq_1
XFILLER_21_165 VPWR VGND sg13cmos5l_fill_1
XFILLER_22_699 VPWR VGND sg13cmos5l_fill_1
XFILLER_21_198 VPWR VGND sg13cmos5l_fill_1
XFILLER_27_1004 VPWR VGND sg13cmos5l_decap_8
XFILLER_49_508 VPWR VGND sg13cmos5l_decap_8
XFILLER_45_725 VPWR VGND sg13cmos5l_decap_4
XFILLER_29_276 VPWR VGND sg13cmos5l_decap_8
XFILLER_44_279 VPWR VGND sg13cmos5l_decap_8
XFILLER_44_257 VPWR VGND sg13cmos5l_fill_1
XFILLER_16_51 VPWR VGND sg13cmos5l_fill_1
XFILLER_26_972 VPWR VGND sg13cmos5l_decap_8
XFILLER_32_408 VPWR VGND sg13cmos5l_decap_8
XFILLER_41_931 VPWR VGND sg13cmos5l_decap_8
XFILLER_12_110 VPWR VGND sg13cmos5l_decap_8
XFILLER_13_633 VPWR VGND sg13cmos5l_decap_8
XFILLER_25_493 VPWR VGND sg13cmos5l_fill_1
XFILLER_9_626 VPWR VGND sg13cmos5l_decap_8
XFILLER_12_154 VPWR VGND sg13cmos5l_fill_2
XFILLER_34_1008 VPWR VGND sg13cmos5l_decap_8
XFILLER_40_485 VPWR VGND sg13cmos5l_decap_8
XFILLER_5_832 VPWR VGND sg13cmos5l_decap_8
XFILLER_4_386 VPWR VGND sg13cmos5l_fill_1
XFILLER_0_570 VPWR VGND sg13cmos5l_fill_1
X_2010_ _2010_/Y _1839_/X _2008_/Y _2196_/A VPWR VGND sg13cmos5l_a21oi_1
XFILLER_36_725 VPWR VGND sg13cmos5l_decap_4
XFILLER_24_909 VPWR VGND sg13cmos5l_decap_8
XFILLER_35_268 VPWR VGND sg13cmos5l_fill_2
XFILLER_16_471 VPWR VGND sg13cmos5l_fill_1
X_2912_ _2912_/Y _2914_/C _2914_/D _2914_/B VPWR VGND sg13cmos5l_a21oi_1
XFILLER_32_920 VPWR VGND sg13cmos5l_decap_8
XFILLER_31_430 VPWR VGND sg13cmos5l_decap_4
X_2843_ _3059_/D _2843_/A _2843_/B _2845_/B VPWR VGND sg13cmos5l_nor3_1
XFILLER_32_997 VPWR VGND sg13cmos5l_decap_8
X_2774_ _2774_/Y _2771_/Y _2772_/Y _2773_/Y VPWR VGND sg13cmos5l_a21oi_1
X_1725_ _1725_/Y _1725_/A _1725_/B _1725_/C VPWR VGND sg13cmos5l_nand3_1
X_1656_ _1661_/B _3133_/Q _1656_/B VPWR VGND sg13cmos5l_xnor2_1
X_1587_ _1722_/C _1633_/B _1619_/C VPWR VGND sg13cmos5l_nand2_1
XFILLER_39_552 VPWR VGND sg13cmos5l_decap_8
XFILLER_2_1006 VPWR VGND sg13cmos5l_decap_8
X_2208_ _2208_/Y _2300_/B _2270_/A _2311_/A VPWR VGND sg13cmos5l_nand3_1
X_2139_ _2139_/Y _2266_/A _2139_/B _2270_/C VPWR VGND sg13cmos5l_nand3_1
XFILLER_14_408 VPWR VGND sg13cmos5l_fill_2
XFILLER_14_419 VPWR VGND sg13cmos5l_fill_1
XFILLER_22_452 VPWR VGND sg13cmos5l_decap_8
XFILLER_23_953 VPWR VGND sg13cmos5l_decap_8
XFILLER_6_618 VPWR VGND sg13cmos5l_decap_8
XFILLER_5_139 VPWR VGND sg13cmos5l_fill_1
XFILLER_2_824 VPWR VGND sg13cmos5l_decap_8
XFILLER_49_338 VPWR VGND sg13cmos5l_decap_8
XFILLER_18_703 VPWR VGND sg13cmos5l_decap_4
XFILLER_18_747 VPWR VGND sg13cmos5l_decap_8
XFILLER_45_577 VPWR VGND sg13cmos5l_decap_8
XFILLER_17_268 VPWR VGND sg13cmos5l_decap_8
XFILLER_32_205 VPWR VGND sg13cmos5l_fill_2
XFILLER_33_706 VPWR VGND sg13cmos5l_decap_8
XFILLER_33_717 VPWR VGND sg13cmos5l_fill_2
XFILLER_32_227 VPWR VGND sg13cmos5l_fill_1
XFILLER_41_761 VPWR VGND sg13cmos5l_decap_4
XFILLER_14_975 VPWR VGND sg13cmos5l_decap_8
XFILLER_43_71 VPWR VGND sg13cmos5l_decap_8
XFILLER_13_463 VPWR VGND sg13cmos5l_fill_1
XFILLER_9_467 VPWR VGND sg13cmos5l_decap_8
X_1510_ _2947_/A _1510_/A VPWR VGND sg13cmos5l_inv_1
X_2490_ _2490_/Y _2490_/A _2490_/B VPWR VGND sg13cmos5l_nor2_1
X_3111_ _3111_/Q _3117_/CLK _3111_/D fanout149/X VPWR VGND sg13cmos5l_dfrbpq_1
XFILLER_4_87 VPWR VGND sg13cmos5l_decap_8
X_3042_ _3042_/Q clkload7/A _3042_/D fanout174/X VPWR VGND sg13cmos5l_dfrbpq_1
XFILLER_36_522 VPWR VGND sg13cmos5l_fill_1
XFILLER_36_555 VPWR VGND sg13cmos5l_decap_8
XFILLER_16_290 VPWR VGND sg13cmos5l_fill_2
XFILLER_23_249 VPWR VGND sg13cmos5l_decap_8
X_2826_ _2828_/B _2827_/A _2827_/B VPWR VGND sg13cmos5l_nor2_1
XFILLER_20_945 VPWR VGND sg13cmos5l_decap_8
X_2757_ _2757_/Y _2757_/A _2757_/B VPWR VGND sg13cmos5l_nor2_1
X_2688_ _2688_/Y _2948_/A _2689_/B VPWR VGND sg13cmos5l_nor2_1
X_1708_ _1709_/C _1732_/B _1708_/B _1821_/B VPWR VGND sg13cmos5l_nand3_1
X_1639_ _1708_/B _1681_/A _1698_/A VPWR VGND sg13cmos5l_nor2_1
XFILLER_24_1007 VPWR VGND sg13cmos5l_decap_8
XFILLER_39_360 VPWR VGND sg13cmos5l_decap_8
XFILLER_15_706 VPWR VGND sg13cmos5l_decap_8
XFILLER_15_739 VPWR VGND sg13cmos5l_decap_4
Xfanout31 _2960_/A _2533_/B VPWR VGND sg13cmos5l_buf_1
XFILLER_11_901 VPWR VGND sg13cmos5l_decap_8
Xfanout20 _1638_/A _1771_/A VPWR VGND sg13cmos5l_buf_1
Xfanout64 _2101_/A _1943_/A VPWR VGND sg13cmos5l_buf_1
Xfanout42 _2151_/B _1887_/Y VPWR VGND sg13cmos5l_buf_1
Xfanout53 _2246_/C _1845_/Y VPWR VGND sg13cmos5l_buf_1
XFILLER_7_916 VPWR VGND sg13cmos5l_decap_8
Xfanout86 _1836_/C _1834_/Y VPWR VGND sg13cmos5l_buf_1
Xfanout75 _2210_/A _2175_/A VPWR VGND sg13cmos5l_buf_1
XFILLER_22_293 VPWR VGND sg13cmos5l_decap_8
Xfanout97 _1696_/A _1705_/B VPWR VGND sg13cmos5l_buf_1
XFILLER_10_466 VPWR VGND sg13cmos5l_decap_8
XFILLER_11_978 VPWR VGND sg13cmos5l_decap_8
XFILLER_6_448 VPWR VGND sg13cmos5l_decap_8
XFILLER_2_621 VPWR VGND sg13cmos5l_decap_8
XFILLER_2_698 VPWR VGND sg13cmos5l_decap_8
XFILLER_49_146 VPWR VGND sg13cmos5l_decap_8
XFILLER_38_809 VPWR VGND sg13cmos5l_decap_4
XFILLER_49_179 VPWR VGND sg13cmos5l_decap_8
XFILLER_46_820 VPWR VGND sg13cmos5l_fill_1
XFILLER_38_82 VPWR VGND sg13cmos5l_fill_1
XFILLER_18_555 VPWR VGND sg13cmos5l_decap_8
XFILLER_46_897 VPWR VGND sg13cmos5l_decap_8
XFILLER_33_514 VPWR VGND sg13cmos5l_decap_8
X_1990_ _2232_/A _1974_/C _1989_/Y _2131_/C VPWR VGND sg13cmos5l_o21ai_1
XFILLER_33_547 VPWR VGND sg13cmos5l_decap_4
XFILLER_20_208 VPWR VGND sg13cmos5l_decap_8
XFILLER_9_231 VPWR VGND sg13cmos5l_decap_8
XFILLER_13_293 VPWR VGND sg13cmos5l_fill_2
XFILLER_9_253 VPWR VGND sg13cmos5l_decap_4
X_2611_ _2614_/B _2612_/A _2612_/B VPWR VGND sg13cmos5l_nand2_1
X_2542_ _2568_/B _2543_/B VPWR VGND sg13cmos5l_inv_1
XFILLER_47_1007 VPWR VGND sg13cmos5l_decap_8
X_2473_ _2473_/Y _2473_/A _3023_/Q VPWR VGND sg13cmos5l_nor2_1
XFILLER_28_319 VPWR VGND sg13cmos5l_fill_1
X_3025_ _3025_/Q _3099_/CLK _3025_/D fanout152/X VPWR VGND sg13cmos5l_dfrbpq_1
XFILLER_36_352 VPWR VGND sg13cmos5l_decap_8
XFILLER_11_208 VPWR VGND sg13cmos5l_decap_8
Xclkload6 clkload6/Y clkload6/A VPWR VGND sg13cmos5l_inv_1
X_2809_ _2809_/Y _3047_/Q _2807_/B _1507_/A VPWR VGND sg13cmos5l_a21oi_1
XFILLER_8_1012 VPWR VGND sg13cmos5l_decap_8
XFILLER_43_801 VPWR VGND sg13cmos5l_decap_8
XFILLER_27_341 VPWR VGND sg13cmos5l_decap_8
XFILLER_28_853 VPWR VGND sg13cmos5l_decap_8
XFILLER_42_311 VPWR VGND sg13cmos5l_fill_2
XFILLER_42_300 VPWR VGND sg13cmos5l_fill_2
XFILLER_43_878 VPWR VGND sg13cmos5l_decap_8
XFILLER_42_388 VPWR VGND sg13cmos5l_decap_8
XFILLER_30_528 VPWR VGND sg13cmos5l_fill_1
XFILLER_7_713 VPWR VGND sg13cmos5l_decap_8
XFILLER_11_753 VPWR VGND sg13cmos5l_decap_8
XFILLER_10_285 VPWR VGND sg13cmos5l_decap_4
XFILLER_3_952 VPWR VGND sg13cmos5l_decap_8
XFILLER_2_495 VPWR VGND sg13cmos5l_decap_8
XFILLER_49_92 VPWR VGND sg13cmos5l_decap_8
XFILLER_19_842 VPWR VGND sg13cmos5l_fill_2
XFILLER_1_77 VPWR VGND sg13cmos5l_fill_2
XFILLER_1_66 VPWR VGND sg13cmos5l_fill_1
XFILLER_19_864 VPWR VGND sg13cmos5l_decap_4
XFILLER_18_385 VPWR VGND sg13cmos5l_decap_8
XFILLER_33_311 VPWR VGND sg13cmos5l_decap_8
XFILLER_34_889 VPWR VGND sg13cmos5l_decap_8
X_1973_ _1974_/C _2294_/B _2251_/C VPWR VGND sg13cmos5l_nor2_1
XFILLER_33_399 VPWR VGND sg13cmos5l_decap_8
XFILLER_14_1017 VPWR VGND sg13cmos5l_decap_8
XFILLER_14_1028 VPWR VGND sg13cmos5l_fill_1
X_2525_ _2525_/Y _2514_/Y _2963_/C _2524_/Y VPWR VGND sg13cmos5l_o21ai_1
X_2456_ _2456_/Y _2456_/A _2480_/B VPWR VGND sg13cmos5l_nor2_1
XFILLER_29_18 VPWR VGND sg13cmos5l_decap_8
X_2387_ _2387_/Y _2387_/A _2387_/B VPWR VGND sg13cmos5l_nor2_1
XFILLER_28_105 VPWR VGND sg13cmos5l_decap_8
XFILLER_29_606 VPWR VGND sg13cmos5l_decap_8
XFILLER_29_628 VPWR VGND sg13cmos5l_decap_8
XFILLER_37_661 VPWR VGND sg13cmos5l_fill_2
X_3008_ _3008_/Q _3008_/CLK _3008_/D fanout161/X VPWR VGND sg13cmos5l_dfrbpq_1
XFILLER_24_311 VPWR VGND sg13cmos5l_decap_8
XFILLER_24_322 VPWR VGND sg13cmos5l_decap_8
XFILLER_25_845 VPWR VGND sg13cmos5l_fill_1
XFILLER_24_377 VPWR VGND sg13cmos5l_decap_8
XFILLER_24_388 VPWR VGND sg13cmos5l_fill_2
XFILLER_20_583 VPWR VGND sg13cmos5l_decap_8
XFILLER_4_727 VPWR VGND sg13cmos5l_decap_8
XFILLER_3_204 VPWR VGND sg13cmos5l_decap_8
XFILLER_0_922 VPWR VGND sg13cmos5l_decap_8
XFILLER_10_75 VPWR VGND sg13cmos5l_decap_4
XFILLER_47_414 VPWR VGND sg13cmos5l_decap_8
XFILLER_0_999 VPWR VGND sg13cmos5l_decap_8
XFILLER_47_436 VPWR VGND sg13cmos5l_decap_8
XFILLER_19_138 VPWR VGND sg13cmos5l_decap_8
XFILLER_47_469 VPWR VGND sg13cmos5l_decap_8
XFILLER_15_333 VPWR VGND sg13cmos5l_fill_1
XFILLER_16_856 VPWR VGND sg13cmos5l_decap_8
XFILLER_37_1028 VPWR VGND sg13cmos5l_fill_1
XFILLER_37_1017 VPWR VGND sg13cmos5l_decap_8
XFILLER_30_303 VPWR VGND sg13cmos5l_decap_8
XFILLER_31_815 VPWR VGND sg13cmos5l_decap_4
XFILLER_42_185 VPWR VGND sg13cmos5l_fill_1
XFILLER_11_550 VPWR VGND sg13cmos5l_decap_8
XFILLER_30_369 VPWR VGND sg13cmos5l_decap_8
XFILLER_7_532 VPWR VGND sg13cmos5l_decap_4
X_2310_ _2310_/X _1953_/Y _2309_/Y _2317_/A VPWR VGND sg13cmos5l_a21o_1
X_2241_ _2241_/Y _2241_/A _2241_/B VPWR VGND sg13cmos5l_nor2_1
XFILLER_39_926 VPWR VGND sg13cmos5l_decap_8
XFILLER_25_4 VPWR VGND sg13cmos5l_decap_8
X_2172_ _2177_/B _1895_/A _2164_/Y _2171_/Y VPWR VGND sg13cmos5l_o21ai_1
XFILLER_25_119 VPWR VGND sg13cmos5l_decap_8
XFILLER_34_675 VPWR VGND sg13cmos5l_decap_8
XFILLER_22_848 VPWR VGND sg13cmos5l_fill_1
XFILLER_21_358 VPWR VGND sg13cmos5l_decap_8
X_1956_ _2297_/C _2166_/A _2135_/B VPWR VGND sg13cmos5l_nand2_1
X_1887_ _1887_/Y _1845_/A _1845_/B _2118_/B _2246_/B _2011_/D VPWR VGND sg13cmos5l_a221oi_1
X_2508_ _2508_/Y _2508_/A _2963_/A VPWR VGND sg13cmos5l_nor2_1
XFILLER_0_207 VPWR VGND sg13cmos5l_decap_8
X_2439_ _2439_/Y _2439_/A _2439_/B VPWR VGND sg13cmos5l_xnor2_1
XFILLER_44_406 VPWR VGND sg13cmos5l_decap_8
XFILLER_38_981 VPWR VGND sg13cmos5l_decap_8
XFILLER_25_620 VPWR VGND sg13cmos5l_decap_4
XFILLER_40_612 VPWR VGND sg13cmos5l_decap_8
XFILLER_12_303 VPWR VGND sg13cmos5l_decap_8
XFILLER_24_130 VPWR VGND sg13cmos5l_fill_2
XFILLER_40_678 VPWR VGND sg13cmos5l_decap_8
XFILLER_21_892 VPWR VGND sg13cmos5l_decap_8
XFILLER_21_85 VPWR VGND sg13cmos5l_decap_8
XFILLER_0_796 VPWR VGND sg13cmos5l_decap_8
XFILLER_36_929 VPWR VGND sg13cmos5l_decap_8
XFILLER_47_299 VPWR VGND sg13cmos5l_decap_8
XFILLER_46_82 VPWR VGND sg13cmos5l_fill_1
XFILLER_44_995 VPWR VGND sg13cmos5l_decap_8
XFILLER_43_461 VPWR VGND sg13cmos5l_decap_8
XFILLER_15_130 VPWR VGND sg13cmos5l_decap_4
XFILLER_16_653 VPWR VGND sg13cmos5l_fill_1
XFILLER_30_111 VPWR VGND sg13cmos5l_decap_8
X_1810_ _1813_/A _1810_/A _1810_/B _1810_/C _1810_/D VPWR VGND sg13cmos5l_nand4_1
XFILLER_31_667 VPWR VGND sg13cmos5l_decap_8
X_2790_ _2803_/A _3042_/Q _2839_/A VPWR VGND sg13cmos5l_xnor2_1
XFILLER_8_830 VPWR VGND sg13cmos5l_decap_8
XFILLER_7_351 VPWR VGND sg13cmos5l_fill_2
XFILLER_7_340 VPWR VGND sg13cmos5l_decap_8
X_1741_ _1741_/Y _1731_/Y _1737_/Y _1705_/A VPWR VGND sg13cmos5l_a21oi_1
XFILLER_7_373 VPWR VGND sg13cmos5l_decap_8
X_1672_ _1676_/B _1666_/Y _1671_/Y _1740_/A VPWR VGND sg13cmos5l_a21oi_1
Xhold307 _2462_/A _2971_/Q VPWR VGND sg13cmos5l_dlygate4sd3_1
Xhold329 _2824_/A _3053_/Q VPWR VGND sg13cmos5l_dlygate4sd3_1
XFILLER_7_98 VPWR VGND sg13cmos5l_fill_1
Xhold318 _3119_/D _2388_/Y VPWR VGND sg13cmos5l_dlygate4sd3_1
X_2224_ _2225_/C _2214_/Y _2224_/B _2224_/C VPWR VGND sg13cmos5l_nand3b_1
X_2155_ _2156_/D _2032_/A _2153_/X _2150_/Y VPWR VGND sg13cmos5l_a21oi_1
X_2086_ _2290_/C _1872_/Y _2086_/B VPWR VGND sg13cmos5l_nand2b_1
XFILLER_19_480 VPWR VGND sg13cmos5l_decap_8
XFILLER_26_439 VPWR VGND sg13cmos5l_decap_8
XFILLER_34_450 VPWR VGND sg13cmos5l_decap_8
X_2988_ _2988_/Q clkload3/A _2988_/D fanout163/X VPWR VGND sg13cmos5l_dfrbpq_1
XFILLER_10_829 VPWR VGND sg13cmos5l_decap_4
X_1939_ _1946_/A _2227_/B _1938_/Y _2003_/B VPWR VGND sg13cmos5l_a21oi_1
XFILLER_1_505 VPWR VGND sg13cmos5l_fill_2
XFILLER_45_704 VPWR VGND sg13cmos5l_decap_4
XFILLER_45_737 VPWR VGND sg13cmos5l_decap_8
XFILLER_17_417 VPWR VGND sg13cmos5l_decap_8
XFILLER_18_929 VPWR VGND sg13cmos5l_decap_8
XFILLER_29_255 VPWR VGND sg13cmos5l_decap_8
XFILLER_26_951 VPWR VGND sg13cmos5l_decap_8
XFILLER_25_472 VPWR VGND sg13cmos5l_decap_8
XFILLER_12_133 VPWR VGND sg13cmos5l_decap_8
XFILLER_41_987 VPWR VGND sg13cmos5l_decap_8
XFILLER_8_159 VPWR VGND sg13cmos5l_fill_2
XFILLER_8_137 VPWR VGND sg13cmos5l_fill_2
XFILLER_5_811 VPWR VGND sg13cmos5l_decap_8
XFILLER_5_888 VPWR VGND sg13cmos5l_decap_8
XFILLER_4_354 VPWR VGND sg13cmos5l_fill_2
XFILLER_48_520 VPWR VGND sg13cmos5l_fill_1
XFILLER_0_593 VPWR VGND sg13cmos5l_decap_8
XFILLER_36_715 VPWR VGND sg13cmos5l_fill_1
XFILLER_17_984 VPWR VGND sg13cmos5l_decap_8
X_2911_ _2913_/A _2911_/A _2911_/B VPWR VGND sg13cmos5l_nor2_1
XFILLER_32_976 VPWR VGND sg13cmos5l_decap_8
X_2842_ _2845_/B _2842_/A _2842_/B VPWR VGND sg13cmos5l_and2_1
X_2773_ _2773_/Y _2771_/Y _2772_/Y _2645_/Y VPWR VGND sg13cmos5l_o21ai_1
X_1724_ _1725_/C _1719_/Y _1721_/X _3127_/Q VPWR VGND sg13cmos5l_a21oi_1
XFILLER_7_192 VPWR VGND sg13cmos5l_decap_8
X_1655_ _1748_/B _3133_/Q _3132_/Q _1655_/C VPWR VGND sg13cmos5l_nor3_1
X_1586_ _1619_/C _1726_/B _1585_/B _1646_/C VPWR VGND sg13cmos5l_o21ai_1
X_2207_ _2207_/Y _2317_/A _2323_/C VPWR VGND sg13cmos5l_nor2_1
X_2138_ _2270_/C _2138_/A _2151_/B VPWR VGND sg13cmos5l_nand2_1
X_2069_ _2076_/B _2268_/A _2240_/A VPWR VGND sg13cmos5l_nand2_1
XFILLER_26_247 VPWR VGND sg13cmos5l_decap_8
XFILLER_23_932 VPWR VGND sg13cmos5l_decap_8
XFILLER_22_431 VPWR VGND sg13cmos5l_decap_8
XFILLER_2_803 VPWR VGND sg13cmos5l_decap_8
Xclkbuf_5_13__f_clk clkload3/A clkbuf_4_6_0_clk/X VPWR VGND sg13cmos5l_buf_8
XFILLER_1_302 VPWR VGND sg13cmos5l_fill_2
XFILLER_1_335 VPWR VGND sg13cmos5l_fill_1
XFILLER_49_317 VPWR VGND sg13cmos5l_decap_8
XFILLER_45_512 VPWR VGND sg13cmos5l_decap_4
XFILLER_40_1024 VPWR VGND sg13cmos5l_decap_4
XFILLER_17_214 VPWR VGND sg13cmos5l_decap_8
XFILLER_26_770 VPWR VGND sg13cmos5l_fill_1
XFILLER_32_239 VPWR VGND sg13cmos5l_decap_8
XFILLER_43_50 VPWR VGND sg13cmos5l_decap_8
XFILLER_14_954 VPWR VGND sg13cmos5l_decap_8
XFILLER_25_291 VPWR VGND sg13cmos5l_fill_1
XFILLER_9_413 VPWR VGND sg13cmos5l_fill_2
XFILLER_9_446 VPWR VGND sg13cmos5l_decap_8
XFILLER_5_685 VPWR VGND sg13cmos5l_decap_8
X_3110_ _3110_/Q _3117_/CLK _3110_/D fanout149/X VPWR VGND sg13cmos5l_dfrbpq_1
XFILLER_0_390 VPWR VGND sg13cmos5l_decap_8
XFILLER_1_891 VPWR VGND sg13cmos5l_decap_8
XFILLER_49_895 VPWR VGND sg13cmos5l_decap_8
X_3041_ _3041_/Q _3057_/CLK _3041_/D fanout173/X VPWR VGND sg13cmos5l_dfrbpq_1
XFILLER_36_512 VPWR VGND sg13cmos5l_fill_1
XFILLER_17_1026 VPWR VGND sg13cmos5l_fill_2
XFILLER_20_924 VPWR VGND sg13cmos5l_decap_8
XFILLER_32_762 VPWR VGND sg13cmos5l_decap_4
X_2825_ _3053_/D _2843_/A _2825_/B _2827_/B VPWR VGND sg13cmos5l_nor3_1
X_2756_ _2761_/A _2756_/A _2778_/B VPWR VGND sg13cmos5l_xnor2_1
X_1707_ _1710_/C _1723_/B _1818_/B VPWR VGND sg13cmos5l_nor2b_1
X_2687_ _2689_/B _2717_/B _2685_/Y _2686_/Y VPWR VGND sg13cmos5l_o21ai_1
X_1638_ _1644_/C _1638_/A _1638_/B _1638_/C _1638_/D VPWR VGND sg13cmos5l_nand4_1
X_1569_ _1604_/A _1638_/A _1638_/B VPWR VGND sg13cmos5l_nand2_1
Xfanout21 _1771_/A _1559_/X VPWR VGND sg13cmos5l_buf_1
Xfanout10 _2886_/A1 _2856_/Y VPWR VGND sg13cmos5l_buf_1
Xfanout65 _1943_/A _1842_/Y VPWR VGND sg13cmos5l_buf_1
Xfanout54 _2078_/B fanout58/X VPWR VGND sg13cmos5l_buf_1
XFILLER_10_401 VPWR VGND sg13cmos5l_decap_8
Xfanout43 _2221_/A _1884_/Y VPWR VGND sg13cmos5l_buf_1
XFILLER_22_250 VPWR VGND sg13cmos5l_decap_8
Xfanout32 _1681_/A _1722_/A VPWR VGND sg13cmos5l_buf_1
XFILLER_23_773 VPWR VGND sg13cmos5l_fill_2
Xfanout87 _2118_/B _2599_/A VPWR VGND sg13cmos5l_buf_1
Xfanout76 _2268_/A _2175_/A VPWR VGND sg13cmos5l_buf_1
XFILLER_10_423 VPWR VGND sg13cmos5l_decap_8
XFILLER_11_957 VPWR VGND sg13cmos5l_decap_8
Xfanout98 _2183_/B _1480_/Y VPWR VGND sg13cmos5l_buf_1
XFILLER_22_272 VPWR VGND sg13cmos5l_decap_8
XFILLER_13_64 VPWR VGND sg13cmos5l_fill_2
XFILLER_13_75 VPWR VGND sg13cmos5l_decap_4
XFILLER_13_97 VPWR VGND sg13cmos5l_decap_8
XFILLER_2_600 VPWR VGND sg13cmos5l_decap_8
XFILLER_1_121 VPWR VGND sg13cmos5l_decap_8
XFILLER_2_677 VPWR VGND sg13cmos5l_decap_8
XFILLER_49_125 VPWR VGND sg13cmos5l_decap_8
XFILLER_1_198 VPWR VGND sg13cmos5l_decap_4
XFILLER_18_501 VPWR VGND sg13cmos5l_decap_8
XFILLER_46_876 VPWR VGND sg13cmos5l_decap_8
XFILLER_14_784 VPWR VGND sg13cmos5l_fill_2
XFILLER_41_592 VPWR VGND sg13cmos5l_decap_8
XFILLER_9_210 VPWR VGND sg13cmos5l_decap_8
XFILLER_13_272 VPWR VGND sg13cmos5l_decap_8
X_2610_ _3020_/D _2615_/A _2610_/B _2612_/B VPWR VGND sg13cmos5l_nor3_1
X_2541_ _2543_/B _2992_/Q _2541_/B VPWR VGND sg13cmos5l_nor2_1
X_2472_ _2472_/Y _2472_/A _2472_/B VPWR VGND sg13cmos5l_nor2_1
XFILLER_49_681 VPWR VGND sg13cmos5l_fill_2
X_3024_ _3024_/Q _3122_/CLK _3024_/D fanout153/X VPWR VGND sg13cmos5l_dfrbpq_1
XFILLER_36_342 VPWR VGND sg13cmos5l_fill_2
XFILLER_36_331 VPWR VGND sg13cmos5l_decap_8
XFILLER_36_397 VPWR VGND sg13cmos5l_decap_8
XFILLER_20_721 VPWR VGND sg13cmos5l_fill_2
XFILLER_20_732 VPWR VGND sg13cmos5l_decap_8
XFILLER_32_592 VPWR VGND sg13cmos5l_fill_2
Xclkload7 clkload7/Y clkload7/A VPWR VGND sg13cmos5l_inv_1
XFILLER_20_776 VPWR VGND sg13cmos5l_decap_8
X_2808_ _3047_/D _2843_/A _2808_/B VPWR VGND sg13cmos5l_nor2_1
XFILLER_30_1023 VPWR VGND sg13cmos5l_decap_4
X_2739_ _2759_/A _3038_/Q _3039_/Q _2717_/B VPWR VGND sg13cmos5l_o21ai_1
XFILLER_4_909 VPWR VGND sg13cmos5l_decap_8
XFILLER_46_117 VPWR VGND sg13cmos5l_decap_8
XFILLER_27_320 VPWR VGND sg13cmos5l_decap_8
XFILLER_43_835 VPWR VGND sg13cmos5l_fill_1
XFILLER_15_504 VPWR VGND sg13cmos5l_decap_8
XFILLER_27_397 VPWR VGND sg13cmos5l_decap_8
XFILLER_11_732 VPWR VGND sg13cmos5l_decap_8
XFILLER_23_592 VPWR VGND sg13cmos5l_decap_8
XFILLER_24_52 VPWR VGND sg13cmos5l_fill_2
XFILLER_10_220 VPWR VGND sg13cmos5l_decap_8
XFILLER_6_202 VPWR VGND sg13cmos5l_fill_1
XFILLER_7_769 VPWR VGND sg13cmos5l_decap_8
XFILLER_3_931 VPWR VGND sg13cmos5l_decap_8
XFILLER_2_474 VPWR VGND sg13cmos5l_decap_8
XFILLER_49_71 VPWR VGND sg13cmos5l_decap_8
XFILLER_37_117 VPWR VGND sg13cmos5l_decap_8
XFILLER_34_802 VPWR VGND sg13cmos5l_decap_8
XFILLER_46_695 VPWR VGND sg13cmos5l_decap_4
XFILLER_18_364 VPWR VGND sg13cmos5l_decap_8
XFILLER_34_813 VPWR VGND sg13cmos5l_fill_1
XFILLER_34_868 VPWR VGND sg13cmos5l_fill_2
XFILLER_33_378 VPWR VGND sg13cmos5l_decap_8
X_1972_ _2318_/A _2131_/B _2022_/A _1972_/C VPWR VGND sg13cmos5l_nor3_1
X_2524_ _2524_/Y _2524_/A _2960_/A VPWR VGND sg13cmos5l_nand2_1
XFILLER_46_0 VPWR VGND sg13cmos5l_decap_8
X_2455_ _2455_/Y _2971_/Q _2459_/A _2449_/Y _2635_/A VPWR VGND sg13cmos5l_a22oi_1
X_2386_ _2390_/B _2387_/A _2387_/B VPWR VGND sg13cmos5l_and2_1
XFILLER_37_651 VPWR VGND sg13cmos5l_fill_2
XFILLER_37_640 VPWR VGND sg13cmos5l_decap_8
X_3007_ _3007_/Q _3008_/CLK _3007_/D fanout158/X VPWR VGND sg13cmos5l_dfrbpq_1
XFILLER_37_695 VPWR VGND sg13cmos5l_decap_8
XFILLER_24_356 VPWR VGND sg13cmos5l_decap_8
XFILLER_4_706 VPWR VGND sg13cmos5l_decap_8
XFILLER_0_901 VPWR VGND sg13cmos5l_decap_8
XFILLER_10_98 VPWR VGND sg13cmos5l_decap_8
XFILLER_0_978 VPWR VGND sg13cmos5l_decap_8
XFILLER_48_949 VPWR VGND sg13cmos5l_decap_8
XFILLER_19_117 VPWR VGND sg13cmos5l_decap_8
XFILLER_19_128 VPWR VGND sg13cmos5l_decap_4
XFILLER_16_824 VPWR VGND sg13cmos5l_decap_8
XFILLER_35_51 VPWR VGND sg13cmos5l_decap_8
XFILLER_15_345 VPWR VGND sg13cmos5l_decap_8
XFILLER_43_698 VPWR VGND sg13cmos5l_decap_4
XFILLER_30_348 VPWR VGND sg13cmos5l_decap_8
XFILLER_11_584 VPWR VGND sg13cmos5l_decap_8
XFILLER_7_588 VPWR VGND sg13cmos5l_fill_2
XFILLER_7_577 VPWR VGND sg13cmos5l_decap_8
XFILLER_2_282 VPWR VGND sg13cmos5l_decap_8
X_2240_ _2241_/B _2240_/A _2240_/B _2240_/C VPWR VGND sg13cmos5l_nor3_1
XFILLER_39_905 VPWR VGND sg13cmos5l_decap_8
XFILLER_18_4 VPWR VGND sg13cmos5l_fill_1
X_2171_ _2171_/Y _2196_/A _2171_/B _2171_/C VPWR VGND sg13cmos5l_nor3_1
XFILLER_19_651 VPWR VGND sg13cmos5l_fill_1
XFILLER_20_1022 VPWR VGND sg13cmos5l_decap_8
XFILLER_47_993 VPWR VGND sg13cmos5l_decap_8
XFILLER_46_470 VPWR VGND sg13cmos5l_decap_8
XFILLER_18_194 VPWR VGND sg13cmos5l_decap_8
XFILLER_34_621 VPWR VGND sg13cmos5l_decap_8
XFILLER_34_654 VPWR VGND sg13cmos5l_decap_8
XFILLER_21_337 VPWR VGND sg13cmos5l_decap_8
XFILLER_33_186 VPWR VGND sg13cmos5l_decap_8
X_1955_ _1955_/Y _1955_/A _1955_/B _1955_/C VPWR VGND sg13cmos5l_nand3_1
X_1886_ _2301_/A _2221_/A _2190_/C VPWR VGND sg13cmos5l_nand2b_1
XFILLER_1_709 VPWR VGND sg13cmos5l_decap_8
X_2507_ _2963_/A _2531_/A _2528_/A VPWR VGND sg13cmos5l_or2_1
X_2438_ _3093_/D _2438_/A _2438_/B VPWR VGND sg13cmos5l_nor2_1
X_2369_ _3136_/D _2369_/A _2365_/B VPWR VGND sg13cmos5l_nor2b_1
XFILLER_45_919 VPWR VGND sg13cmos5l_decap_8
XFILLER_38_960 VPWR VGND sg13cmos5l_decap_8
XFILLER_40_635 VPWR VGND sg13cmos5l_decap_8
XFILLER_24_186 VPWR VGND sg13cmos5l_decap_8
XFILLER_25_687 VPWR VGND sg13cmos5l_decap_8
XFILLER_12_359 VPWR VGND sg13cmos5l_decap_8
XFILLER_20_392 VPWR VGND sg13cmos5l_decap_4
XFILLER_4_514 VPWR VGND sg13cmos5l_fill_1
XFILLER_21_75 VPWR VGND sg13cmos5l_fill_1
XFILLER_43_1011 VPWR VGND sg13cmos5l_decap_8
XFILLER_0_775 VPWR VGND sg13cmos5l_decap_8
XFILLER_36_908 VPWR VGND sg13cmos5l_decap_8
XFILLER_47_289 VPWR VGND sg13cmos5l_fill_1
XFILLER_47_278 VPWR VGND sg13cmos5l_fill_2
XFILLER_29_993 VPWR VGND sg13cmos5l_decap_8
XFILLER_44_974 VPWR VGND sg13cmos5l_decap_8
XFILLER_16_676 VPWR VGND sg13cmos5l_decap_8
XFILLER_43_495 VPWR VGND sg13cmos5l_decap_8
XFILLER_16_687 VPWR VGND sg13cmos5l_fill_1
XFILLER_31_624 VPWR VGND sg13cmos5l_fill_1
XFILLER_15_197 VPWR VGND sg13cmos5l_decap_8
XFILLER_12_860 VPWR VGND sg13cmos5l_decap_4
XFILLER_11_381 VPWR VGND sg13cmos5l_decap_8
X_1740_ _1740_/Y _1740_/A _1740_/B _1740_/C VPWR VGND sg13cmos5l_nand3_1
XFILLER_8_886 VPWR VGND sg13cmos5l_decap_8
XFILLER_7_77 VPWR VGND sg13cmos5l_fill_1
X_1671_ _1671_/Y _1669_/Y _1670_/Y _1817_/A VPWR VGND sg13cmos5l_o21ai_1
Xhold308 hold308/X _2462_/Y VPWR VGND sg13cmos5l_dlygate4sd3_1
Xhold319 _2839_/A _3058_/Q VPWR VGND sg13cmos5l_dlygate4sd3_1
XFILLER_3_580 VPWR VGND sg13cmos5l_decap_4
X_2223_ _2224_/B _2285_/B _2218_/Y _2222_/Y _2263_/A VPWR VGND sg13cmos5l_a22oi_1
XFILLER_39_768 VPWR VGND sg13cmos5l_fill_1
X_2154_ _2156_/C _2267_/A _2169_/B _2151_/Y VPWR VGND sg13cmos5l_a21oi_1
XFILLER_38_289 VPWR VGND sg13cmos5l_fill_1
XFILLER_38_278 VPWR VGND sg13cmos5l_decap_8
XFILLER_26_418 VPWR VGND sg13cmos5l_decap_8
X_2085_ _2281_/A _2404_/A _2404_/B VPWR VGND sg13cmos5l_nor2_1
XFILLER_35_985 VPWR VGND sg13cmos5l_decap_8
XFILLER_10_808 VPWR VGND sg13cmos5l_fill_1
X_2987_ _2987_/Q _3085_/CLK _2987_/D fanout165/X VPWR VGND sg13cmos5l_dfrbpq_1
X_1938_ _1938_/Y _2266_/A _2266_/B VPWR VGND sg13cmos5l_nand2_1
X_1869_ _2204_/A _2294_/B _2148_/B VPWR VGND sg13cmos5l_nor2_1
XFILLER_1_528 VPWR VGND sg13cmos5l_decap_4
XFILLER_18_908 VPWR VGND sg13cmos5l_decap_8
XFILLER_29_234 VPWR VGND sg13cmos5l_decap_8
XFILLER_26_930 VPWR VGND sg13cmos5l_decap_8
XFILLER_16_31 VPWR VGND sg13cmos5l_decap_8
XFILLER_13_602 VPWR VGND sg13cmos5l_decap_8
XFILLER_16_64 VPWR VGND sg13cmos5l_decap_4
XFILLER_16_86 VPWR VGND sg13cmos5l_decap_8
XFILLER_25_484 VPWR VGND sg13cmos5l_decap_8
XFILLER_41_966 VPWR VGND sg13cmos5l_decap_8
XFILLER_13_679 VPWR VGND sg13cmos5l_decap_8
XFILLER_12_189 VPWR VGND sg13cmos5l_decap_8
XFILLER_32_74 VPWR VGND sg13cmos5l_decap_8
XFILLER_10_1021 VPWR VGND sg13cmos5l_decap_8
XFILLER_5_867 VPWR VGND sg13cmos5l_decap_8
XFILLER_35_215 VPWR VGND sg13cmos5l_fill_2
XFILLER_44_760 VPWR VGND sg13cmos5l_decap_8
XFILLER_17_963 VPWR VGND sg13cmos5l_decap_8
X_2910_ _2911_/B _2914_/B _2914_/D _2855_/A VPWR VGND sg13cmos5l_a21oi_1
XFILLER_43_292 VPWR VGND sg13cmos5l_fill_1
XFILLER_16_495 VPWR VGND sg13cmos5l_decap_4
XFILLER_32_955 VPWR VGND sg13cmos5l_decap_8
X_2841_ _2843_/B _2842_/A _2842_/B VPWR VGND sg13cmos5l_nor2_1
X_2772_ _2772_/Y _2763_/Y _2765_/X _2766_/A VPWR VGND sg13cmos5l_a21oi_1
XFILLER_8_683 VPWR VGND sg13cmos5l_decap_8
X_1723_ _1725_/B _1817_/A _1723_/B _1723_/C VPWR VGND sg13cmos5l_nand3_1
X_1654_ _1658_/A _2246_/A _1659_/B VPWR VGND sg13cmos5l_nor2_1
X_1585_ _1602_/C _1726_/B _1585_/B VPWR VGND sg13cmos5l_nor2_1
XFILLER_39_510 VPWR VGND sg13cmos5l_decap_8
X_2206_ _2206_/Y _2201_/Y _2205_/Y _2210_/A VPWR VGND sg13cmos5l_o21ai_1
XFILLER_39_587 VPWR VGND sg13cmos5l_decap_4
XFILLER_39_598 VPWR VGND sg13cmos5l_decap_8
X_2137_ _2137_/Y _2301_/A _2136_/Y _2297_/A VPWR VGND sg13cmos5l_a21oi_1
XFILLER_26_226 VPWR VGND sg13cmos5l_decap_8
X_2068_ _2068_/Y _2175_/A _2101_/A _2308_/C _2308_/D VPWR VGND sg13cmos5l_nor4_1
XFILLER_26_259 VPWR VGND sg13cmos5l_decap_8
XFILLER_22_410 VPWR VGND sg13cmos5l_fill_1
XFILLER_34_270 VPWR VGND sg13cmos5l_decap_4
XFILLER_10_616 VPWR VGND sg13cmos5l_decap_8
XFILLER_23_988 VPWR VGND sg13cmos5l_decap_8
XFILLER_6_609 VPWR VGND sg13cmos5l_decap_4
XFILLER_22_498 VPWR VGND sg13cmos5l_decap_4
XFILLER_2_859 VPWR VGND sg13cmos5l_decap_8
XFILLER_40_1003 VPWR VGND sg13cmos5l_decap_8
XFILLER_18_716 VPWR VGND sg13cmos5l_decap_8
XFILLER_18_727 VPWR VGND sg13cmos5l_fill_2
XFILLER_17_259 VPWR VGND sg13cmos5l_decap_4
XFILLER_27_96 VPWR VGND sg13cmos5l_decap_4
XFILLER_14_933 VPWR VGND sg13cmos5l_decap_8
XFILLER_41_741 VPWR VGND sg13cmos5l_fill_1
XFILLER_13_421 VPWR VGND sg13cmos5l_decap_8
XFILLER_41_774 VPWR VGND sg13cmos5l_fill_2
XFILLER_40_251 VPWR VGND sg13cmos5l_fill_1
XFILLER_9_425 VPWR VGND sg13cmos5l_decap_8
XFILLER_5_664 VPWR VGND sg13cmos5l_decap_8
XFILLER_4_185 VPWR VGND sg13cmos5l_fill_1
XFILLER_4_45 VPWR VGND sg13cmos5l_fill_1
XFILLER_1_870 VPWR VGND sg13cmos5l_decap_8
XFILLER_49_874 VPWR VGND sg13cmos5l_decap_8
X_3040_ _3040_/Q _3057_/CLK _3040_/D fanout170/X VPWR VGND sg13cmos5l_dfrbpq_1
XFILLER_23_229 VPWR VGND sg13cmos5l_decap_8
XFILLER_17_1005 VPWR VGND sg13cmos5l_decap_8
X_2824_ _2827_/B _2824_/A _2824_/B VPWR VGND sg13cmos5l_and2_1
X_2755_ _2755_/Y _2755_/A _2778_/B VPWR VGND sg13cmos5l_nand2_1
X_1706_ _1710_/B _1631_/B _1723_/B _1821_/B VPWR VGND sg13cmos5l_a21oi_1
X_2686_ _2686_/Y _3080_/Q _2686_/B _2686_/C VPWR VGND sg13cmos5l_nand3_1
X_1637_ _1644_/B _1585_/B _1709_/B VPWR VGND sg13cmos5l_nand2b_1
X_1568_ _1726_/B _1584_/A _1570_/C VPWR VGND sg13cmos5l_nor2_1
X_1499_ _2968_/A _1499_/A VPWR VGND sg13cmos5l_inv_1
XFILLER_39_340 VPWR VGND sg13cmos5l_decap_8
XFILLER_27_502 VPWR VGND sg13cmos5l_decap_8
Xfanout22 _2577_/B _2582_/S VPWR VGND sg13cmos5l_buf_1
Xfanout11 _2896_/A _2856_/Y VPWR VGND sg13cmos5l_buf_1
Xfanout44 _2149_/B _1866_/Y VPWR VGND sg13cmos5l_buf_1
Xfanout33 _2393_/A _2398_/A VPWR VGND sg13cmos5l_buf_1
Xfanout55 _2166_/A fanout58/X VPWR VGND sg13cmos5l_buf_1
XFILLER_23_752 VPWR VGND sg13cmos5l_decap_8
Xfanout88 _1919_/B _1865_/A VPWR VGND sg13cmos5l_buf_1
Xfanout77 _2175_/A _1835_/X VPWR VGND sg13cmos5l_buf_1
Xfanout99 _2602_/A _1480_/Y VPWR VGND sg13cmos5l_buf_1
XFILLER_11_936 VPWR VGND sg13cmos5l_decap_8
XFILLER_13_32 VPWR VGND sg13cmos5l_fill_1
Xfanout66 _2300_/B _1985_/B VPWR VGND sg13cmos5l_buf_1
XFILLER_6_439 VPWR VGND sg13cmos5l_fill_1
XFILLER_6_428 VPWR VGND sg13cmos5l_decap_8
XFILLER_2_656 VPWR VGND sg13cmos5l_decap_8
XFILLER_1_166 VPWR VGND sg13cmos5l_fill_2
XFILLER_45_376 VPWR VGND sg13cmos5l_decap_4
XFILLER_14_752 VPWR VGND sg13cmos5l_decap_8
X_2540_ _2541_/B _2990_/Q _2993_/Q _2991_/Q VPWR VGND sg13cmos5l_nand3b_1
XFILLER_6_984 VPWR VGND sg13cmos5l_decap_8
XFILLER_5_472 VPWR VGND sg13cmos5l_decap_8
X_2471_ _2471_/Y _2472_/B _2469_/Y _2470_/Y VPWR VGND sg13cmos5l_a21oi_1
XFILLER_49_660 VPWR VGND sg13cmos5l_decap_8
XFILLER_37_822 VPWR VGND sg13cmos5l_fill_2
X_3023_ _3023_/Q _3099_/CLK _3023_/D fanout153/X VPWR VGND sg13cmos5l_dfrbpq_1
XFILLER_24_549 VPWR VGND sg13cmos5l_decap_8
XFILLER_20_700 VPWR VGND sg13cmos5l_decap_8
XFILLER_32_560 VPWR VGND sg13cmos5l_decap_8
XFILLER_20_755 VPWR VGND sg13cmos5l_decap_8
X_2807_ _2807_/Y _2807_/A _2807_/B VPWR VGND sg13cmos5l_xnor2_1
XFILLER_20_799 VPWR VGND sg13cmos5l_decap_8
XFILLER_30_1002 VPWR VGND sg13cmos5l_decap_8
X_2738_ _2757_/A _3040_/Q _2749_/B VPWR VGND sg13cmos5l_xnor2_1
X_2669_ _2942_/B _2934_/C _2669_/B VPWR VGND sg13cmos5l_nand2b_1
XFILLER_39_170 VPWR VGND sg13cmos5l_decap_8
XFILLER_27_376 VPWR VGND sg13cmos5l_decap_8
XFILLER_28_888 VPWR VGND sg13cmos5l_decap_8
XFILLER_42_313 VPWR VGND sg13cmos5l_fill_1
XFILLER_42_379 VPWR VGND sg13cmos5l_decap_4
XFILLER_30_519 VPWR VGND sg13cmos5l_decap_8
XFILLER_11_711 VPWR VGND sg13cmos5l_decap_8
XFILLER_7_748 VPWR VGND sg13cmos5l_decap_8
XFILLER_6_225 VPWR VGND sg13cmos5l_decap_8
XFILLER_10_265 VPWR VGND sg13cmos5l_decap_4
XFILLER_11_799 VPWR VGND sg13cmos5l_decap_8
XFILLER_40_74 VPWR VGND sg13cmos5l_decap_8
XFILLER_3_910 VPWR VGND sg13cmos5l_decap_8
XFILLER_3_987 VPWR VGND sg13cmos5l_decap_8
XFILLER_2_453 VPWR VGND sg13cmos5l_decap_8
XFILLER_49_50 VPWR VGND sg13cmos5l_decap_8
XFILLER_38_608 VPWR VGND sg13cmos5l_decap_8
XFILLER_37_107 VPWR VGND sg13cmos5l_fill_1
XFILLER_46_652 VPWR VGND sg13cmos5l_decap_4
XFILLER_46_630 VPWR VGND sg13cmos5l_decap_8
XFILLER_1_79 VPWR VGND sg13cmos5l_fill_1
XFILLER_18_343 VPWR VGND sg13cmos5l_decap_8
XFILLER_19_844 VPWR VGND sg13cmos5l_fill_1
XFILLER_46_674 VPWR VGND sg13cmos5l_decap_8
XFILLER_19_888 VPWR VGND sg13cmos5l_decap_8
XFILLER_45_184 VPWR VGND sg13cmos5l_decap_8
XFILLER_33_357 VPWR VGND sg13cmos5l_decap_8
X_1971_ _2031_/B _2138_/A _1971_/B VPWR VGND sg13cmos5l_nand2_1
XFILLER_14_571 VPWR VGND sg13cmos5l_decap_4
X_2523_ _2983_/D _2963_/A _2963_/C _2522_/Y VPWR VGND sg13cmos5l_o21ai_1
XFILLER_6_781 VPWR VGND sg13cmos5l_decap_8
X_2454_ _2480_/B _2619_/B _2454_/B VPWR VGND sg13cmos5l_nor2_1
X_2385_ _3118_/D _2393_/A _2385_/B _2387_/B VPWR VGND sg13cmos5l_nor3_1
Xinput1 input1/X rst_n VPWR VGND sg13cmos5l_buf_1
X_3006_ _3006_/Q _3013_/CLK _3006_/D fanout158/X VPWR VGND sg13cmos5l_dfrbpq_1
XFILLER_37_674 VPWR VGND sg13cmos5l_decap_8
XFILLER_36_140 VPWR VGND sg13cmos5l_fill_2
XFILLER_25_836 VPWR VGND sg13cmos5l_decap_8
XFILLER_25_858 VPWR VGND sg13cmos5l_decap_8
XFILLER_10_11 VPWR VGND sg13cmos5l_decap_8
XFILLER_10_66 VPWR VGND sg13cmos5l_decap_4
XFILLER_10_88 VPWR VGND sg13cmos5l_decap_4
XFILLER_0_957 VPWR VGND sg13cmos5l_decap_8
XFILLER_48_928 VPWR VGND sg13cmos5l_decap_8
XFILLER_27_162 VPWR VGND sg13cmos5l_decap_8
XFILLER_28_674 VPWR VGND sg13cmos5l_decap_8
XFILLER_43_633 VPWR VGND sg13cmos5l_decap_4
XFILLER_43_677 VPWR VGND sg13cmos5l_decap_8
XFILLER_15_368 VPWR VGND sg13cmos5l_decap_8
XFILLER_42_176 VPWR VGND sg13cmos5l_decap_8
XFILLER_42_165 VPWR VGND sg13cmos5l_fill_2
XFILLER_35_96 VPWR VGND sg13cmos5l_fill_1
XFILLER_3_784 VPWR VGND sg13cmos5l_decap_8
XFILLER_2_261 VPWR VGND sg13cmos5l_decap_8
XFILLER_32_7 VPWR VGND sg13cmos5l_decap_8
XFILLER_38_427 VPWR VGND sg13cmos5l_decap_8
XFILLER_38_405 VPWR VGND sg13cmos5l_decap_4
X_2170_ _2171_/C _2023_/A _2169_/Y _1883_/Y VPWR VGND sg13cmos5l_a21oi_1
XFILLER_20_1001 VPWR VGND sg13cmos5l_decap_8
XFILLER_47_972 VPWR VGND sg13cmos5l_decap_8
XFILLER_33_143 VPWR VGND sg13cmos5l_fill_1
XFILLER_21_305 VPWR VGND sg13cmos5l_decap_8
XFILLER_22_839 VPWR VGND sg13cmos5l_decap_8
X_1954_ _1955_/C _2251_/A _2149_/B _2063_/A VPWR VGND sg13cmos5l_nand3_1
XFILLER_30_883 VPWR VGND sg13cmos5l_decap_8
X_1885_ _2190_/C _1943_/A _1907_/A VPWR VGND sg13cmos5l_nor2_1
X_2506_ _2528_/A _2515_/C _2512_/C _2515_/D VPWR VGND sg13cmos5l_nor3_1
X_2437_ _2437_/X _2437_/A _2437_/B VPWR VGND sg13cmos5l_xor2_1
XFILLER_5_1028 VPWR VGND sg13cmos5l_fill_1
X_2368_ _3134_/D _2368_/A _2368_/B VPWR VGND sg13cmos5l_and2_1
XFILLER_29_416 VPWR VGND sg13cmos5l_decap_8
X_2299_ _2300_/D _2317_/A _2299_/B VPWR VGND sg13cmos5l_nand2_1
XFILLER_25_666 VPWR VGND sg13cmos5l_decap_8
XFILLER_40_625 VPWR VGND sg13cmos5l_decap_4
XFILLER_13_828 VPWR VGND sg13cmos5l_decap_8
XFILLER_24_165 VPWR VGND sg13cmos5l_decap_8
XFILLER_8_309 VPWR VGND sg13cmos5l_decap_8
XFILLER_12_338 VPWR VGND sg13cmos5l_decap_8
XFILLER_20_360 VPWR VGND sg13cmos5l_decap_8
XFILLER_0_754 VPWR VGND sg13cmos5l_decap_8
XFILLER_48_758 VPWR VGND sg13cmos5l_fill_1
XFILLER_35_419 VPWR VGND sg13cmos5l_decap_8
XFILLER_29_972 VPWR VGND sg13cmos5l_decap_8
XFILLER_46_62 VPWR VGND sg13cmos5l_decap_8
XFILLER_16_633 VPWR VGND sg13cmos5l_fill_2
XFILLER_28_471 VPWR VGND sg13cmos5l_decap_8
XFILLER_44_953 VPWR VGND sg13cmos5l_decap_8
XFILLER_16_699 VPWR VGND sg13cmos5l_decap_8
Xclkbuf_5_0__f_clk _3117_/CLK clkbuf_4_0_0_clk/X VPWR VGND sg13cmos5l_buf_8
XFILLER_31_647 VPWR VGND sg13cmos5l_fill_1
XFILLER_30_168 VPWR VGND sg13cmos5l_decap_8
XFILLER_30_179 VPWR VGND sg13cmos5l_fill_2
XFILLER_8_865 VPWR VGND sg13cmos5l_decap_8
XFILLER_11_360 VPWR VGND sg13cmos5l_decap_8
X_1670_ _1670_/Y _1698_/A _1722_/D VPWR VGND sg13cmos5l_nor2_1
Xhold309 _2971_/D _2463_/Y VPWR VGND sg13cmos5l_dlygate4sd3_1
XFILLER_7_89 VPWR VGND sg13cmos5l_fill_1
XFILLER_30_4 VPWR VGND sg13cmos5l_decap_8
X_2222_ _2222_/Y _2222_/A _2222_/B _2222_/C _2222_/D VPWR VGND sg13cmos5l_nand4_1
X_2153_ _2153_/X _2153_/A _2153_/B VPWR VGND sg13cmos5l_and2_1
XFILLER_38_257 VPWR VGND sg13cmos5l_decap_8
XFILLER_19_460 VPWR VGND sg13cmos5l_decap_8
X_2084_ _2088_/A _2322_/A _2067_/Y _2083_/Y VPWR VGND sg13cmos5l_o21ai_1
XFILLER_35_964 VPWR VGND sg13cmos5l_decap_8
XFILLER_34_485 VPWR VGND sg13cmos5l_decap_8
XFILLER_21_113 VPWR VGND sg13cmos5l_fill_2
XFILLER_22_647 VPWR VGND sg13cmos5l_decap_8
X_2986_ _2986_/Q _3036_/CLK _2986_/D fanout163/X VPWR VGND sg13cmos5l_dfrbpq_1
X_1937_ _2266_/B _2308_/B _2063_/B VPWR VGND sg13cmos5l_or2_1
X_1868_ _2148_/B _2598_/A _2240_/B VPWR VGND sg13cmos5l_and2_1
X_1799_ _1814_/A _3064_/Q _1799_/B VPWR VGND sg13cmos5l_xor2_1
XFILLER_27_1018 VPWR VGND sg13cmos5l_decap_8
XFILLER_29_213 VPWR VGND sg13cmos5l_decap_8
XFILLER_25_452 VPWR VGND sg13cmos5l_decap_8
XFILLER_26_986 VPWR VGND sg13cmos5l_decap_8
XFILLER_41_945 VPWR VGND sg13cmos5l_decap_8
XFILLER_13_658 VPWR VGND sg13cmos5l_decap_8
XFILLER_12_168 VPWR VGND sg13cmos5l_decap_8
XFILLER_32_31 VPWR VGND sg13cmos5l_decap_8
XFILLER_40_499 VPWR VGND sg13cmos5l_fill_2
XFILLER_8_139 VPWR VGND sg13cmos5l_fill_1
XFILLER_10_1000 VPWR VGND sg13cmos5l_decap_8
XFILLER_32_97 VPWR VGND sg13cmos5l_decap_8
XFILLER_5_846 VPWR VGND sg13cmos5l_decap_8
XFILLER_4_323 VPWR VGND sg13cmos5l_fill_2
XFILLER_4_301 VPWR VGND sg13cmos5l_fill_1
XFILLER_4_367 VPWR VGND sg13cmos5l_fill_1
XFILLER_48_555 VPWR VGND sg13cmos5l_fill_2
XFILLER_29_780 VPWR VGND sg13cmos5l_decap_8
XFILLER_16_430 VPWR VGND sg13cmos5l_decap_4
XFILLER_16_441 VPWR VGND sg13cmos5l_decap_8
XFILLER_17_942 VPWR VGND sg13cmos5l_decap_8
XFILLER_32_934 VPWR VGND sg13cmos5l_decap_8
XFILLER_43_271 VPWR VGND sg13cmos5l_decap_8
X_2840_ _2840_/Y _2843_/A _2840_/B _2842_/B VPWR VGND sg13cmos5l_nor3_1
X_2771_ _2771_/Y _2771_/A _2778_/B VPWR VGND sg13cmos5l_xnor2_1
XFILLER_12_691 VPWR VGND sg13cmos5l_fill_2
X_1722_ _1723_/C _1722_/A _1722_/B _1722_/C _1722_/D VPWR VGND sg13cmos5l_or4_1
XFILLER_7_172 VPWR VGND sg13cmos5l_decap_8
X_1653_ _1659_/B _3132_/Q _1655_/C VPWR VGND sg13cmos5l_xor2_1
X_1584_ _1585_/B _1584_/A _1599_/A _1604_/B VPWR VGND sg13cmos5l_nor3_1
X_2205_ _2205_/Y _2205_/A _2205_/B VPWR VGND sg13cmos5l_nor2_1
XFILLER_39_566 VPWR VGND sg13cmos5l_decap_8
X_2136_ _2136_/Y _2202_/C _2002_/B _2135_/Y _2003_/C VPWR VGND sg13cmos5l_a22oi_1
XFILLER_26_205 VPWR VGND sg13cmos5l_decap_8
X_2067_ _2067_/Y _2210_/A _2066_/Y _2060_/Y VPWR VGND sg13cmos5l_o21ai_1
XFILLER_41_208 VPWR VGND sg13cmos5l_fill_1
XFILLER_23_967 VPWR VGND sg13cmos5l_decap_8
X_2969_ _2969_/Q clkload1/A _2969_/D fanout159/X VPWR VGND sg13cmos5l_dfrbpq_1
XFILLER_2_838 VPWR VGND sg13cmos5l_decap_8
XFILLER_1_304 VPWR VGND sg13cmos5l_fill_1
XFILLER_1_326 VPWR VGND sg13cmos5l_fill_1
XFILLER_45_536 VPWR VGND sg13cmos5l_decap_4
XFILLER_17_205 VPWR VGND sg13cmos5l_decap_4
XFILLER_17_238 VPWR VGND sg13cmos5l_decap_8
XFILLER_27_64 VPWR VGND sg13cmos5l_decap_8
XFILLER_14_912 VPWR VGND sg13cmos5l_decap_8
XFILLER_40_230 VPWR VGND sg13cmos5l_decap_8
XFILLER_9_415 VPWR VGND sg13cmos5l_fill_1
XFILLER_13_444 VPWR VGND sg13cmos5l_decap_8
XFILLER_13_455 VPWR VGND sg13cmos5l_fill_2
XFILLER_14_989 VPWR VGND sg13cmos5l_decap_8
XFILLER_43_85 VPWR VGND sg13cmos5l_decap_8
XFILLER_5_621 VPWR VGND sg13cmos5l_fill_2
XFILLER_4_164 VPWR VGND sg13cmos5l_decap_8
XFILLER_49_853 VPWR VGND sg13cmos5l_decap_8
XFILLER_36_503 VPWR VGND sg13cmos5l_fill_2
XFILLER_36_569 VPWR VGND sg13cmos5l_decap_8
XFILLER_17_772 VPWR VGND sg13cmos5l_decap_8
XFILLER_17_783 VPWR VGND sg13cmos5l_fill_1
XFILLER_17_1028 VPWR VGND sg13cmos5l_fill_1
X_2823_ _2823_/Y _2824_/A _2824_/B VPWR VGND sg13cmos5l_nor2_1
XFILLER_20_959 VPWR VGND sg13cmos5l_decap_8
X_2754_ _2754_/X _2756_/A _2754_/B VPWR VGND sg13cmos5l_and2_1
XFILLER_8_481 VPWR VGND sg13cmos5l_decap_8
XFILLER_9_982 VPWR VGND sg13cmos5l_decap_8
X_1705_ _1821_/B _1705_/A _1705_/B _1705_/C VPWR VGND sg13cmos5l_nor3_1
X_2685_ _2685_/Y _2442_/B _2442_/C _2672_/A VPWR VGND sg13cmos5l_a21oi_1
X_1636_ _1636_/Y _1705_/A _1817_/A _1723_/B VPWR VGND sg13cmos5l_a21oi_1
X_1567_ _1570_/C _1567_/A _1567_/B VPWR VGND sg13cmos5l_xnor2_1
X_1498_ _2370_/A _2412_/C VPWR VGND sg13cmos5l_inv_1
XFILLER_39_374 VPWR VGND sg13cmos5l_decap_4
XFILLER_39_396 VPWR VGND sg13cmos5l_decap_8
X_2119_ _2121_/A _1907_/A _1856_/Y _2036_/B _2118_/Y VPWR VGND sg13cmos5l_a22oi_1
X_3099_ _3099_/Q _3099_/CLK _3099_/D fanout154/X VPWR VGND sg13cmos5l_dfrbpq_1
XFILLER_14_219 VPWR VGND sg13cmos5l_decap_8
XFILLER_35_591 VPWR VGND sg13cmos5l_decap_4
XFILLER_35_580 VPWR VGND sg13cmos5l_decap_8
Xfanout12 _2902_/B _2879_/B VPWR VGND sg13cmos5l_buf_1
Xfanout23 _2582_/S _2570_/Y VPWR VGND sg13cmos5l_buf_1
Xfanout56 _2308_/A fanout58/X VPWR VGND sg13cmos5l_buf_1
Xfanout45 _2135_/A _1856_/Y VPWR VGND sg13cmos5l_buf_1
XFILLER_11_915 VPWR VGND sg13cmos5l_decap_8
Xfanout34 _2194_/B _2131_/C VPWR VGND sg13cmos5l_buf_1
Xfanout89 _1865_/A _1828_/X VPWR VGND sg13cmos5l_buf_1
XFILLER_13_11 VPWR VGND sg13cmos5l_decap_8
Xfanout67 _2196_/B _1985_/B VPWR VGND sg13cmos5l_buf_1
Xfanout78 _2362_/A _2367_/A VPWR VGND sg13cmos5l_buf_1
XFILLER_8_4 VPWR VGND sg13cmos5l_decap_4
XFILLER_2_635 VPWR VGND sg13cmos5l_decap_4
XFILLER_38_41 VPWR VGND sg13cmos5l_fill_1
XFILLER_45_333 VPWR VGND sg13cmos5l_decap_8
XFILLER_18_569 VPWR VGND sg13cmos5l_decap_4
XFILLER_45_355 VPWR VGND sg13cmos5l_fill_2
XFILLER_13_252 VPWR VGND sg13cmos5l_decap_8
XFILLER_41_583 VPWR VGND sg13cmos5l_fill_1
XFILLER_41_572 VPWR VGND sg13cmos5l_decap_8
XFILLER_9_267 VPWR VGND sg13cmos5l_decap_8
XFILLER_6_963 VPWR VGND sg13cmos5l_decap_8
X_2470_ _2470_/Y _2470_/A _2472_/B VPWR VGND sg13cmos5l_nor2_1
XFILLER_5_495 VPWR VGND sg13cmos5l_fill_1
X_3022_ _3022_/Q clkload4/A _3022_/D fanout167/X VPWR VGND sg13cmos5l_dfrbpq_1
XFILLER_37_867 VPWR VGND sg13cmos5l_fill_2
XFILLER_20_723 VPWR VGND sg13cmos5l_fill_1
X_2806_ _3046_/D _2807_/B _2806_/B _2822_/A VPWR VGND sg13cmos5l_nor3_1
X_2737_ _3039_/D _2947_/A _2747_/A _2659_/Y _2736_/X VPWR VGND sg13cmos5l_a22oi_1
X_2668_ _2933_/B _2934_/C _2669_/B VPWR VGND sg13cmos5l_nor2b_1
X_1619_ _1628_/B _1696_/A _1732_/B _1619_/C VPWR VGND sg13cmos5l_nand3_1
X_2599_ _2605_/D _2599_/A _2599_/B VPWR VGND sg13cmos5l_nor2_1
XFILLER_8_1026 VPWR VGND sg13cmos5l_fill_2
XFILLER_28_867 VPWR VGND sg13cmos5l_decap_8
XFILLER_43_815 VPWR VGND sg13cmos5l_decap_8
XFILLER_27_355 VPWR VGND sg13cmos5l_decap_8
XFILLER_42_336 VPWR VGND sg13cmos5l_fill_1
XFILLER_42_325 VPWR VGND sg13cmos5l_decap_8
XFILLER_15_539 VPWR VGND sg13cmos5l_decap_8
XFILLER_42_358 VPWR VGND sg13cmos5l_decap_8
XFILLER_23_583 VPWR VGND sg13cmos5l_decap_4
XFILLER_10_211 VPWR VGND sg13cmos5l_decap_4
XFILLER_10_244 VPWR VGND sg13cmos5l_decap_8
XFILLER_11_767 VPWR VGND sg13cmos5l_decap_8
XFILLER_7_727 VPWR VGND sg13cmos5l_decap_8
XFILLER_40_53 VPWR VGND sg13cmos5l_decap_8
XFILLER_6_259 VPWR VGND sg13cmos5l_fill_2
XFILLER_6_248 VPWR VGND sg13cmos5l_decap_8
XFILLER_2_432 VPWR VGND sg13cmos5l_decap_8
XFILLER_3_966 VPWR VGND sg13cmos5l_decap_8
XFILLER_19_812 VPWR VGND sg13cmos5l_fill_2
XFILLER_19_823 VPWR VGND sg13cmos5l_decap_8
XFILLER_18_322 VPWR VGND sg13cmos5l_decap_8
XFILLER_45_163 VPWR VGND sg13cmos5l_decap_8
XFILLER_18_399 VPWR VGND sg13cmos5l_decap_4
XFILLER_33_336 VPWR VGND sg13cmos5l_decap_8
XFILLER_34_848 VPWR VGND sg13cmos5l_decap_4
X_1970_ _1970_/Y _2101_/A _2251_/C VPWR VGND sg13cmos5l_nor2_1
XFILLER_14_550 VPWR VGND sg13cmos5l_decap_8
XFILLER_42_881 VPWR VGND sg13cmos5l_decap_8
X_2522_ _2522_/Y _2522_/A _2529_/A VPWR VGND sg13cmos5l_nand2_1
XFILLER_6_760 VPWR VGND sg13cmos5l_decap_8
X_2453_ _2454_/B _2459_/A _2635_/A VPWR VGND sg13cmos5l_nor2_1
X_2384_ _2387_/B _2384_/A _2384_/B VPWR VGND sg13cmos5l_and2_1
Xinput2 input2/X ui_in[0] VPWR VGND sg13cmos5l_buf_1
XFILLER_28_119 VPWR VGND sg13cmos5l_fill_2
X_3005_ _3005_/Q _3009_/CLK _3005_/D fanout157/X VPWR VGND sg13cmos5l_dfrbpq_1
XFILLER_24_336 VPWR VGND sg13cmos5l_decap_8
XFILLER_24_347 VPWR VGND sg13cmos5l_fill_2
XFILLER_20_520 VPWR VGND sg13cmos5l_decap_4
XFILLER_3_218 VPWR VGND sg13cmos5l_decap_8
XFILLER_0_936 VPWR VGND sg13cmos5l_decap_8
XFILLER_48_907 VPWR VGND sg13cmos5l_decap_8
XFILLER_47_428 VPWR VGND sg13cmos5l_decap_4
XFILLER_43_601 VPWR VGND sg13cmos5l_fill_2
XFILLER_42_100 VPWR VGND sg13cmos5l_decap_4
XFILLER_15_303 VPWR VGND sg13cmos5l_decap_8
XFILLER_27_185 VPWR VGND sg13cmos5l_decap_8
XFILLER_43_656 VPWR VGND sg13cmos5l_decap_8
XFILLER_24_881 VPWR VGND sg13cmos5l_decap_8
XFILLER_11_531 VPWR VGND sg13cmos5l_decap_8
XFILLER_11_542 VPWR VGND sg13cmos5l_fill_1
XFILLER_23_380 VPWR VGND sg13cmos5l_fill_1
Xclkbuf_5_19__f_clk _3093_/CLK clkbuf_4_9_0_clk/X VPWR VGND sg13cmos5l_buf_8
XFILLER_11_564 VPWR VGND sg13cmos5l_decap_4
XFILLER_3_763 VPWR VGND sg13cmos5l_decap_8
XFILLER_2_240 VPWR VGND sg13cmos5l_fill_2
XFILLER_47_951 VPWR VGND sg13cmos5l_decap_8
XFILLER_18_163 VPWR VGND sg13cmos5l_decap_8
XFILLER_18_174 VPWR VGND sg13cmos5l_fill_1
XFILLER_19_697 VPWR VGND sg13cmos5l_decap_8
XFILLER_22_807 VPWR VGND sg13cmos5l_decap_8
XFILLER_22_818 VPWR VGND sg13cmos5l_fill_2
XFILLER_33_122 VPWR VGND sg13cmos5l_decap_8
XFILLER_33_155 VPWR VGND sg13cmos5l_decap_8
XFILLER_34_689 VPWR VGND sg13cmos5l_decap_8
X_1953_ _1953_/Y _2149_/B _2063_/A VPWR VGND sg13cmos5l_nand2_1
X_1884_ _1884_/Y _1845_/A _1845_/B _1861_/Y _2602_/A VPWR VGND sg13cmos5l_a22oi_1
XFILLER_30_862 VPWR VGND sg13cmos5l_decap_8
X_2505_ _2515_/D _2995_/Q _2996_/Q VPWR VGND sg13cmos5l_nand2_1
X_2436_ _2439_/B _2641_/D _2436_/B VPWR VGND sg13cmos5l_nand2b_1
XFILLER_5_1007 VPWR VGND sg13cmos5l_decap_8
X_2367_ _2368_/B _2367_/A _2369_/A VPWR VGND sg13cmos5l_xnor2_1
X_2298_ _2299_/B _2183_/C _2036_/B _2178_/A VPWR VGND sg13cmos5l_a21oi_1
XFILLER_38_995 VPWR VGND sg13cmos5l_decap_8
XFILLER_37_472 VPWR VGND sg13cmos5l_decap_8
XFILLER_24_111 VPWR VGND sg13cmos5l_decap_8
XFILLER_24_144 VPWR VGND sg13cmos5l_decap_8
XFILLER_36_1020 VPWR VGND sg13cmos5l_decap_8
XFILLER_12_317 VPWR VGND sg13cmos5l_fill_2
XFILLER_21_862 VPWR VGND sg13cmos5l_decap_8
XFILLER_21_33 VPWR VGND sg13cmos5l_decap_4
XFILLER_21_55 VPWR VGND sg13cmos5l_fill_2
XFILLER_21_66 VPWR VGND sg13cmos5l_decap_8
XFILLER_21_99 VPWR VGND sg13cmos5l_decap_8
XFILLER_0_733 VPWR VGND sg13cmos5l_decap_8
XFILLER_29_951 VPWR VGND sg13cmos5l_decap_8
XFILLER_44_932 VPWR VGND sg13cmos5l_decap_8
XFILLER_16_601 VPWR VGND sg13cmos5l_decap_8
XFILLER_46_96 VPWR VGND sg13cmos5l_decap_8
XFILLER_43_442 VPWR VGND sg13cmos5l_fill_1
XFILLER_43_431 VPWR VGND sg13cmos5l_decap_8
XFILLER_43_475 VPWR VGND sg13cmos5l_decap_8
XFILLER_15_155 VPWR VGND sg13cmos5l_decap_8
XFILLER_31_604 VPWR VGND sg13cmos5l_decap_8
XFILLER_30_147 VPWR VGND sg13cmos5l_decap_8
XFILLER_8_844 VPWR VGND sg13cmos5l_decap_8
XFILLER_7_321 VPWR VGND sg13cmos5l_decap_4
XFILLER_12_884 VPWR VGND sg13cmos5l_decap_8
X_2221_ _2222_/D _2221_/A _2221_/B VPWR VGND sg13cmos5l_nand2_1
XFILLER_23_4 VPWR VGND sg13cmos5l_decap_8
XFILLER_39_759 VPWR VGND sg13cmos5l_decap_8
XFILLER_38_214 VPWR VGND sg13cmos5l_fill_2
X_2152_ _2153_/B _2152_/A _2002_/B VPWR VGND sg13cmos5l_nor2b_1
X_2083_ _2083_/Y _2083_/A _2156_/B _2083_/C VPWR VGND sg13cmos5l_nand3_1
XFILLER_47_792 VPWR VGND sg13cmos5l_decap_4
XFILLER_47_770 VPWR VGND sg13cmos5l_decap_4
XFILLER_35_943 VPWR VGND sg13cmos5l_decap_8
XFILLER_19_494 VPWR VGND sg13cmos5l_decap_8
XFILLER_34_464 VPWR VGND sg13cmos5l_decap_8
X_2985_ _2985_/Q clkload3/A _2985_/D fanout163/X VPWR VGND sg13cmos5l_dfrbpq_1
XFILLER_21_158 VPWR VGND sg13cmos5l_decap_8
X_1936_ _2063_/B _2244_/A _2594_/A _1845_/A _1845_/B _1861_/Y VPWR VGND sg13cmos5l_a221oi_1
XFILLER_30_692 VPWR VGND sg13cmos5l_decap_8
X_1867_ _2240_/B _1776_/Y _1836_/C _2259_/A _1919_/B _1847_/Y VPWR VGND sg13cmos5l_a221oi_1
X_1798_ _1799_/B _2669_/B _2934_/C _1805_/B VPWR VGND sg13cmos5l_a21oi_1
X_2419_ _2419_/Y _2419_/A _2419_/B VPWR VGND sg13cmos5l_nor2_1
XFILLER_29_269 VPWR VGND sg13cmos5l_decap_8
XFILLER_16_11 VPWR VGND sg13cmos5l_decap_8
XFILLER_26_965 VPWR VGND sg13cmos5l_decap_8
XFILLER_41_924 VPWR VGND sg13cmos5l_decap_8
XFILLER_13_626 VPWR VGND sg13cmos5l_decap_8
XFILLER_12_103 VPWR VGND sg13cmos5l_decap_8
XFILLER_40_478 VPWR VGND sg13cmos5l_decap_8
XFILLER_8_107 VPWR VGND sg13cmos5l_decap_4
XFILLER_9_619 VPWR VGND sg13cmos5l_decap_8
XFILLER_12_147 VPWR VGND sg13cmos5l_decap_8
XFILLER_5_825 VPWR VGND sg13cmos5l_decap_8
XFILLER_4_379 VPWR VGND sg13cmos5l_decap_8
XFILLER_0_552 VPWR VGND sg13cmos5l_decap_8
XFILLER_48_512 VPWR VGND sg13cmos5l_fill_2
XFILLER_36_729 VPWR VGND sg13cmos5l_fill_1
XFILLER_17_921 VPWR VGND sg13cmos5l_decap_8
XFILLER_43_250 VPWR VGND sg13cmos5l_decap_8
XFILLER_16_464 VPWR VGND sg13cmos5l_decap_8
XFILLER_17_998 VPWR VGND sg13cmos5l_decap_8
XFILLER_32_913 VPWR VGND sg13cmos5l_decap_8
XFILLER_31_434 VPWR VGND sg13cmos5l_fill_2
X_2770_ _2770_/Y _3044_/Q _2778_/B VPWR VGND sg13cmos5l_nand2_1
XFILLER_31_489 VPWR VGND sg13cmos5l_decap_4
X_1721_ _1721_/X _1733_/A _1721_/B VPWR VGND sg13cmos5l_and2_1
XFILLER_7_151 VPWR VGND sg13cmos5l_decap_8
X_1652_ _1656_/B _3132_/Q _1655_/C VPWR VGND sg13cmos5l_nor2_1
X_1583_ _1604_/B _1583_/A _1583_/B VPWR VGND sg13cmos5l_xnor2_1
XFILLER_3_390 VPWR VGND sg13cmos5l_decap_8
X_2204_ _2205_/B _2204_/A _2257_/B VPWR VGND sg13cmos5l_nor2b_1
XFILLER_39_545 VPWR VGND sg13cmos5l_decap_8
X_2135_ _2135_/Y _2135_/A _2135_/B VPWR VGND sg13cmos5l_nand2_1
XFILLER_35_751 VPWR VGND sg13cmos5l_fill_1
X_2066_ _2066_/Y _2267_/A _2054_/A _2002_/Y _2065_/Y _2064_/Y VPWR VGND sg13cmos5l_a221oi_1
XFILLER_23_946 VPWR VGND sg13cmos5l_decap_8
XFILLER_22_445 VPWR VGND sg13cmos5l_decap_8
XFILLER_22_478 VPWR VGND sg13cmos5l_fill_2
X_2968_ _2968_/Y _2968_/A _2968_/B VPWR VGND sg13cmos5l_xnor2_1
XFILLER_31_990 VPWR VGND sg13cmos5l_decap_8
XFILLER_33_1012 VPWR VGND sg13cmos5l_decap_8
X_1919_ _2202_/C _1972_/C _1919_/B VPWR VGND sg13cmos5l_nor2_1
X_2899_ _2903_/B _3075_/Q _2900_/B VPWR VGND sg13cmos5l_and2_1
XFILLER_2_817 VPWR VGND sg13cmos5l_decap_8
XFILLER_17_228 VPWR VGND sg13cmos5l_decap_4
XFILLER_43_20 VPWR VGND sg13cmos5l_decap_8
XFILLER_41_732 VPWR VGND sg13cmos5l_decap_8
XFILLER_25_272 VPWR VGND sg13cmos5l_decap_8
XFILLER_43_64 VPWR VGND sg13cmos5l_decap_8
XFILLER_14_968 VPWR VGND sg13cmos5l_decap_8
XFILLER_5_611 VPWR VGND sg13cmos5l_fill_2
XFILLER_5_600 VPWR VGND sg13cmos5l_decap_8
XFILLER_4_132 VPWR VGND sg13cmos5l_decap_8
XFILLER_5_699 VPWR VGND sg13cmos5l_decap_8
XFILLER_4_154 VPWR VGND sg13cmos5l_fill_2
XFILLER_4_198 VPWR VGND sg13cmos5l_decap_8
XFILLER_49_832 VPWR VGND sg13cmos5l_decap_8
XFILLER_0_371 VPWR VGND sg13cmos5l_decap_8
XFILLER_36_548 VPWR VGND sg13cmos5l_decap_8
XFILLER_1_1010 VPWR VGND sg13cmos5l_decap_8
XFILLER_17_751 VPWR VGND sg13cmos5l_decap_8
XFILLER_44_570 VPWR VGND sg13cmos5l_fill_2
XFILLER_32_721 VPWR VGND sg13cmos5l_decap_8
XFILLER_32_732 VPWR VGND sg13cmos5l_decap_8
X_2822_ _2822_/Y _2822_/A _2822_/B _2824_/B VPWR VGND sg13cmos5l_nor3_1
XFILLER_20_938 VPWR VGND sg13cmos5l_decap_8
X_2753_ _2753_/X hold426/X _2754_/B _2752_/Y VPWR VGND sg13cmos5l_a21o_1
XFILLER_9_961 VPWR VGND sg13cmos5l_decap_8
X_1704_ _1704_/Y _1821_/A _1703_/X _1823_/A VPWR VGND sg13cmos5l_a21oi_1
X_2684_ _3033_/D _2920_/A _2648_/A _2682_/Y _2683_/Y VPWR VGND sg13cmos5l_a22oi_1
X_1635_ _1723_/B _1635_/A _1635_/B VPWR VGND sg13cmos5l_nand2_1
X_1566_ _1638_/B _1567_/A _1567_/B VPWR VGND sg13cmos5l_xor2_1
X_1497_ _2199_/A _2404_/A VPWR VGND sg13cmos5l_inv_1
X_3098_ _3098_/Q _3099_/CLK _3098_/D fanout152/X VPWR VGND sg13cmos5l_dfrbpq_1
X_2118_ _2118_/Y _2118_/A _2118_/B VPWR VGND sg13cmos5l_nor2_1
XFILLER_27_548 VPWR VGND sg13cmos5l_fill_2
X_2049_ _2049_/Y _2063_/A _2221_/A _2266_/B _1970_/Y _2047_/C VPWR VGND sg13cmos5l_a221oi_1
XFILLER_23_710 VPWR VGND sg13cmos5l_decap_4
Xfanout13 _2879_/B _2911_/A VPWR VGND sg13cmos5l_buf_1
Xfanout24 _2843_/A _2822_/A VPWR VGND sg13cmos5l_buf_1
Xfanout46 _2138_/A _2186_/C VPWR VGND sg13cmos5l_buf_1
Xfanout35 _2131_/C _1988_/Y VPWR VGND sg13cmos5l_buf_1
Xfanout68 _2267_/A _1985_/B VPWR VGND sg13cmos5l_buf_1
Xfanout57 _2183_/C fanout58/X VPWR VGND sg13cmos5l_buf_1
XFILLER_22_286 VPWR VGND sg13cmos5l_decap_8
Xfanout79 _2367_/A _1531_/Y VPWR VGND sg13cmos5l_buf_1
XFILLER_7_909 VPWR VGND sg13cmos5l_decap_8
XFILLER_10_437 VPWR VGND sg13cmos5l_decap_4
XFILLER_10_459 VPWR VGND sg13cmos5l_decap_8
XFILLER_2_614 VPWR VGND sg13cmos5l_decap_8
Xhold460 _3084_/D _2961_/Y VPWR VGND sg13cmos5l_dlygate4sd3_1
XFILLER_49_139 VPWR VGND sg13cmos5l_decap_8
XFILLER_45_301 VPWR VGND sg13cmos5l_decap_8
XFILLER_18_515 VPWR VGND sg13cmos5l_fill_2
XFILLER_18_548 VPWR VGND sg13cmos5l_decap_8
XFILLER_33_507 VPWR VGND sg13cmos5l_decap_8
XFILLER_14_743 VPWR VGND sg13cmos5l_decap_4
XFILLER_9_224 VPWR VGND sg13cmos5l_decap_8
XFILLER_9_246 VPWR VGND sg13cmos5l_decap_8
XFILLER_13_286 VPWR VGND sg13cmos5l_decap_8
XFILLER_6_942 VPWR VGND sg13cmos5l_decap_8
XFILLER_10_993 VPWR VGND sg13cmos5l_decap_8
X_3021_ _3021_/Q clkload4/A _3021_/D fanout167/X VPWR VGND sg13cmos5l_dfrbpq_1
XFILLER_49_695 VPWR VGND sg13cmos5l_decap_8
XFILLER_48_183 VPWR VGND sg13cmos5l_decap_4
XFILLER_37_879 VPWR VGND sg13cmos5l_decap_4
XFILLER_36_378 VPWR VGND sg13cmos5l_decap_4
XFILLER_32_540 VPWR VGND sg13cmos5l_decap_8
X_2805_ _2850_/B _2851_/B _2805_/B _2805_/C _2805_/D VPWR VGND sg13cmos5l_nor4_1
XFILLER_20_746 VPWR VGND sg13cmos5l_decap_4
X_2736_ _2736_/X _2741_/C _2734_/Y _2735_/Y VPWR VGND sg13cmos5l_a21o_1
X_2667_ _3032_/D _2664_/A _2730_/B1 _2659_/Y _2666_/X VPWR VGND sg13cmos5l_a22oi_1
X_1618_ _1618_/Y _1581_/Y _1611_/Y _1617_/Y VPWR VGND sg13cmos5l_o21ai_1
XFILLER_8_1005 VPWR VGND sg13cmos5l_decap_8
X_2598_ _2615_/A _2598_/A _2599_/B _2598_/C _2598_/D VPWR VGND sg13cmos5l_nor4_1
X_1549_ _1575_/A _1567_/A _1567_/B _1542_/Y VPWR VGND sg13cmos5l_a21oi_1
XFILLER_27_334 VPWR VGND sg13cmos5l_decap_8
XFILLER_28_846 VPWR VGND sg13cmos5l_decap_8
XFILLER_15_518 VPWR VGND sg13cmos5l_fill_1
XFILLER_24_11 VPWR VGND sg13cmos5l_decap_4
XFILLER_10_234 VPWR VGND sg13cmos5l_decap_4
XFILLER_11_746 VPWR VGND sg13cmos5l_decap_8
XFILLER_10_278 VPWR VGND sg13cmos5l_decap_8
XFILLER_3_945 VPWR VGND sg13cmos5l_decap_8
XFILLER_2_488 VPWR VGND sg13cmos5l_decap_8
Xhold290 _3075_/D _2901_/Y VPWR VGND sg13cmos5l_dlygate4sd3_1
XFILLER_49_85 VPWR VGND sg13cmos5l_decap_8
XFILLER_18_301 VPWR VGND sg13cmos5l_decap_8
XFILLER_19_857 VPWR VGND sg13cmos5l_decap_8
XFILLER_45_142 VPWR VGND sg13cmos5l_decap_8
XFILLER_19_868 VPWR VGND sg13cmos5l_fill_1
XFILLER_18_378 VPWR VGND sg13cmos5l_decap_8
XFILLER_33_304 VPWR VGND sg13cmos5l_decap_8
XFILLER_42_860 VPWR VGND sg13cmos5l_decap_8
XFILLER_14_584 VPWR VGND sg13cmos5l_decap_4
XFILLER_10_790 VPWR VGND sg13cmos5l_fill_2
X_2521_ _2982_/D _1521_/Y _2529_/A _2520_/Y VPWR VGND sg13cmos5l_a21oi_1
X_2452_ _2635_/A _3029_/Q _3028_/Q VPWR VGND sg13cmos5l_nor2b_1
XFILLER_5_293 VPWR VGND sg13cmos5l_decap_8
X_2383_ _2385_/B _2384_/A _2384_/B VPWR VGND sg13cmos5l_nor2_1
X_3004_ _3004_/Q _3009_/CLK _3004_/D fanout157/X VPWR VGND sg13cmos5l_dfrbpq_1
Xinput3 input3/X ui_in[1] VPWR VGND sg13cmos5l_buf_1
XFILLER_25_805 VPWR VGND sg13cmos5l_decap_4
XFILLER_24_304 VPWR VGND sg13cmos5l_decap_8
XFILLER_33_893 VPWR VGND sg13cmos5l_decap_8
XFILLER_20_576 VPWR VGND sg13cmos5l_decap_8
XFILLER_20_598 VPWR VGND sg13cmos5l_decap_8
X_2719_ _2719_/Y _2715_/Y _2718_/Y _2856_/B VPWR VGND sg13cmos5l_o21ai_1
XFILLER_10_35 VPWR VGND sg13cmos5l_decap_4
XFILLER_10_79 VPWR VGND sg13cmos5l_fill_1
XFILLER_0_915 VPWR VGND sg13cmos5l_decap_8
XFILLER_19_11 VPWR VGND sg13cmos5l_decap_8
XFILLER_16_805 VPWR VGND sg13cmos5l_fill_2
XFILLER_16_816 VPWR VGND sg13cmos5l_decap_4
XFILLER_16_838 VPWR VGND sg13cmos5l_fill_1
XFILLER_16_849 VPWR VGND sg13cmos5l_decap_8
XFILLER_35_21 VPWR VGND sg13cmos5l_fill_1
XFILLER_24_860 VPWR VGND sg13cmos5l_decap_8
XFILLER_7_525 VPWR VGND sg13cmos5l_decap_8
XFILLER_11_598 VPWR VGND sg13cmos5l_decap_8
XFILLER_3_742 VPWR VGND sg13cmos5l_decap_8
XFILLER_39_919 VPWR VGND sg13cmos5l_decap_8
XFILLER_2_296 VPWR VGND sg13cmos5l_decap_8
XFILLER_47_930 VPWR VGND sg13cmos5l_decap_8
XFILLER_18_142 VPWR VGND sg13cmos5l_decap_8
XFILLER_33_101 VPWR VGND sg13cmos5l_decap_8
XFILLER_34_602 VPWR VGND sg13cmos5l_decap_8
XFILLER_34_668 VPWR VGND sg13cmos5l_decap_8
XFILLER_15_860 VPWR VGND sg13cmos5l_fill_2
X_1952_ _1955_/B _1985_/B _2240_/A _2311_/A _1952_/D VPWR VGND sg13cmos5l_nand4_1
XFILLER_15_893 VPWR VGND sg13cmos5l_decap_8
XFILLER_30_841 VPWR VGND sg13cmos5l_decap_8
X_1883_ _1883_/Y _2294_/A _2196_/B VPWR VGND sg13cmos5l_nand2_1
XFILLER_44_0 VPWR VGND sg13cmos5l_decap_8
X_2504_ _2512_/C _2998_/Q _2997_/Q VPWR VGND sg13cmos5l_or2_1
X_2435_ _3092_/D _2435_/A VPWR VGND sg13cmos5l_inv_1
X_2366_ _3133_/D _2369_/A _2366_/B VPWR VGND sg13cmos5l_xor2_1
Xclkbuf_5_25__f_clk clkload6/A clkbuf_4_12_0_clk/X VPWR VGND sg13cmos5l_buf_8
X_2297_ _2300_/C _2297_/A _2297_/B _2297_/C VPWR VGND sg13cmos5l_nand3_1
XFILLER_29_429 VPWR VGND sg13cmos5l_decap_8
XFILLER_38_974 VPWR VGND sg13cmos5l_decap_8
XFILLER_37_451 VPWR VGND sg13cmos5l_decap_8
XFILLER_25_613 VPWR VGND sg13cmos5l_decap_8
XFILLER_25_624 VPWR VGND sg13cmos5l_fill_1
XFILLER_40_605 VPWR VGND sg13cmos5l_fill_2
XFILLER_40_649 VPWR VGND sg13cmos5l_decap_4
XFILLER_21_841 VPWR VGND sg13cmos5l_decap_8
XFILLER_21_885 VPWR VGND sg13cmos5l_decap_8
XFILLER_4_539 VPWR VGND sg13cmos5l_fill_2
XFILLER_0_712 VPWR VGND sg13cmos5l_decap_8
XFILLER_43_1025 VPWR VGND sg13cmos5l_decap_4
XFILLER_0_789 VPWR VGND sg13cmos5l_decap_8
XFILLER_29_930 VPWR VGND sg13cmos5l_decap_8
XFILLER_44_911 VPWR VGND sg13cmos5l_decap_8
XFILLER_15_112 VPWR VGND sg13cmos5l_decap_8
XFILLER_15_123 VPWR VGND sg13cmos5l_fill_2
XFILLER_15_134 VPWR VGND sg13cmos5l_fill_1
XFILLER_16_646 VPWR VGND sg13cmos5l_decap_8
XFILLER_44_988 VPWR VGND sg13cmos5l_decap_8
XFILLER_43_454 VPWR VGND sg13cmos5l_decap_8
XFILLER_30_104 VPWR VGND sg13cmos5l_decap_8
XFILLER_8_823 VPWR VGND sg13cmos5l_decap_8
XFILLER_7_333 VPWR VGND sg13cmos5l_fill_2
XFILLER_7_366 VPWR VGND sg13cmos5l_decap_8
XFILLER_7_399 VPWR VGND sg13cmos5l_decap_8
X_2220_ _2222_/C _2178_/A _2194_/C _2054_/B VPWR VGND sg13cmos5l_o21ai_1
X_2151_ _2151_/Y _2153_/A _2151_/B _2151_/C VPWR VGND sg13cmos5l_nor3_1
XFILLER_16_4 VPWR VGND sg13cmos5l_decap_8
X_2082_ _2083_/C _2082_/A _2082_/B _2082_/C VPWR VGND sg13cmos5l_nor3_1
XFILLER_19_451 VPWR VGND sg13cmos5l_fill_1
XFILLER_35_922 VPWR VGND sg13cmos5l_decap_8
XFILLER_34_443 VPWR VGND sg13cmos5l_decap_8
XFILLER_35_999 VPWR VGND sg13cmos5l_decap_8
X_2984_ _2984_/Q clkload3/A _2984_/D fanout161/X VPWR VGND sg13cmos5l_dfrbpq_1
X_1935_ _2227_/B _2138_/A _1908_/C _2308_/A VPWR VGND sg13cmos5l_o21ai_1
XFILLER_21_137 VPWR VGND sg13cmos5l_decap_4
XFILLER_30_682 VPWR VGND sg13cmos5l_decap_4
X_1866_ _1866_/Y _1862_/A _1862_/B _1845_/A _1845_/B _2011_/D VPWR VGND sg13cmos5l_a221oi_1
X_1797_ _2934_/C _1800_/A _2919_/A VPWR VGND sg13cmos5l_xnor2_1
X_2418_ _2418_/Y _2417_/A _2417_/B _2599_/B VPWR VGND sg13cmos5l_o21ai_1
X_2349_ _2350_/C _2596_/A _2440_/B _2349_/C VPWR VGND sg13cmos5l_nor3_1
XFILLER_29_248 VPWR VGND sg13cmos5l_decap_8
XFILLER_44_218 VPWR VGND sg13cmos5l_decap_4
XFILLER_25_443 VPWR VGND sg13cmos5l_fill_2
XFILLER_26_944 VPWR VGND sg13cmos5l_decap_8
XFILLER_12_126 VPWR VGND sg13cmos5l_fill_2
XFILLER_21_671 VPWR VGND sg13cmos5l_decap_8
XFILLER_5_804 VPWR VGND sg13cmos5l_decap_8
XFILLER_4_325 VPWR VGND sg13cmos5l_fill_1
XFILLER_4_336 VPWR VGND sg13cmos5l_decap_4
XFILLER_0_531 VPWR VGND sg13cmos5l_decap_8
XFILLER_48_524 VPWR VGND sg13cmos5l_decap_4
XFILLER_0_586 VPWR VGND sg13cmos5l_decap_8
XFILLER_48_557 VPWR VGND sg13cmos5l_fill_1
XFILLER_17_900 VPWR VGND sg13cmos5l_decap_8
XFILLER_29_760 VPWR VGND sg13cmos5l_decap_8
XFILLER_44_730 VPWR VGND sg13cmos5l_decap_4
XFILLER_44_774 VPWR VGND sg13cmos5l_fill_1
XFILLER_17_977 VPWR VGND sg13cmos5l_decap_8
XFILLER_32_969 VPWR VGND sg13cmos5l_decap_8
XFILLER_12_660 VPWR VGND sg13cmos5l_decap_8
XFILLER_12_682 VPWR VGND sg13cmos5l_fill_1
X_1720_ _1721_/B _1720_/A _1720_/B _1733_/B VPWR VGND sg13cmos5l_nand3_1
XFILLER_8_697 VPWR VGND sg13cmos5l_decap_8
X_1651_ _1733_/A _1705_/B _1718_/B VPWR VGND sg13cmos5l_nor2_1
XFILLER_7_185 VPWR VGND sg13cmos5l_fill_2
X_1582_ _1638_/D _1583_/A _1583_/B VPWR VGND sg13cmos5l_xor2_1
XFILLER_4_881 VPWR VGND sg13cmos5l_decap_8
XFILLER_39_524 VPWR VGND sg13cmos5l_decap_4
X_2203_ _2257_/B _1866_/Y _2190_/C _2202_/Y VPWR VGND sg13cmos5l_a21oi_1
X_2134_ _2134_/Y _2129_/Y _2133_/Y _2128_/Y VPWR VGND sg13cmos5l_o21ai_1
X_2065_ _2065_/Y _2148_/A _2065_/B VPWR VGND sg13cmos5l_nor2_1
XFILLER_23_925 VPWR VGND sg13cmos5l_decap_8
XFILLER_22_424 VPWR VGND sg13cmos5l_decap_8
X_2967_ _2968_/B _2967_/A _2967_/B VPWR VGND sg13cmos5l_nor2_1
X_1918_ _1918_/Y _2196_/B _2054_/A _2173_/A _2294_/A _1916_/Y VPWR VGND sg13cmos5l_a221oi_1
X_2898_ _2898_/Y _2900_/A _2902_/B VPWR VGND sg13cmos5l_nand2_1
X_1849_ _2202_/B _1844_/A _1844_/B _1889_/A VPWR VGND sg13cmos5l_o21ai_1
XFILLER_40_1028 VPWR VGND sg13cmos5l_fill_1
XFILLER_40_1017 VPWR VGND sg13cmos5l_decap_8
XFILLER_27_11 VPWR VGND sg13cmos5l_decap_8
XFILLER_45_505 VPWR VGND sg13cmos5l_decap_8
XFILLER_26_763 VPWR VGND sg13cmos5l_fill_1
XFILLER_14_947 VPWR VGND sg13cmos5l_decap_8
XFILLER_25_262 VPWR VGND sg13cmos5l_decap_4
XFILLER_25_284 VPWR VGND sg13cmos5l_decap_8
XFILLER_9_406 VPWR VGND sg13cmos5l_decap_8
XFILLER_13_435 VPWR VGND sg13cmos5l_decap_4
XFILLER_13_468 VPWR VGND sg13cmos5l_decap_4
XFILLER_9_439 VPWR VGND sg13cmos5l_decap_8
XFILLER_13_479 VPWR VGND sg13cmos5l_decap_4
XFILLER_5_678 VPWR VGND sg13cmos5l_decap_8
XFILLER_4_15 VPWR VGND sg13cmos5l_decap_8
XFILLER_49_811 VPWR VGND sg13cmos5l_decap_8
XFILLER_0_350 VPWR VGND sg13cmos5l_decap_8
XFILLER_1_884 VPWR VGND sg13cmos5l_decap_8
XFILLER_49_888 VPWR VGND sg13cmos5l_decap_8
XFILLER_16_273 VPWR VGND sg13cmos5l_fill_1
XFILLER_17_796 VPWR VGND sg13cmos5l_decap_8
XFILLER_17_1019 VPWR VGND sg13cmos5l_decap_8
XFILLER_20_917 VPWR VGND sg13cmos5l_decap_8
XFILLER_32_755 VPWR VGND sg13cmos5l_decap_8
XFILLER_32_766 VPWR VGND sg13cmos5l_fill_2
X_2821_ _2824_/B _2821_/A _2821_/B VPWR VGND sg13cmos5l_and2_1
XFILLER_32_799 VPWR VGND sg13cmos5l_decap_8
X_2752_ _2752_/Y _2757_/B _2750_/Y _2751_/Y VPWR VGND sg13cmos5l_a21oi_1
XFILLER_9_940 VPWR VGND sg13cmos5l_decap_8
X_1703_ _1703_/X _1618_/Y _1631_/Y _1636_/Y VPWR VGND sg13cmos5l_a21o_1
X_2683_ _2683_/Y _1500_/A _1521_/A _2730_/B1 VPWR VGND sg13cmos5l_a21oi_1
X_1634_ _1635_/B _1740_/A _1697_/D _1739_/B VPWR VGND sg13cmos5l_nor3_1
X_1565_ _1570_/B _1583_/B _1599_/A VPWR VGND sg13cmos5l_and2_1
X_1496_ _1496_/Y _2323_/A VPWR VGND sg13cmos5l_inv_1
X_2117_ _2160_/B _2224_/C _2116_/Y _2100_/X VPWR VGND sg13cmos5l_a21oi_1
X_3097_ _3097_/Q _3099_/CLK _3097_/D fanout152/X VPWR VGND sg13cmos5l_dfrbpq_1
X_2048_ _2048_/Y _2259_/B _2221_/A VPWR VGND sg13cmos5l_nand2_1
XFILLER_23_733 VPWR VGND sg13cmos5l_decap_8
Xfanout25 _2822_/A _2850_/B VPWR VGND sg13cmos5l_buf_1
Xfanout47 _2186_/C _2202_/B VPWR VGND sg13cmos5l_buf_1
Xfanout36 _2169_/B _1970_/Y VPWR VGND sg13cmos5l_buf_1
Xfanout14 _1632_/A _1726_/D VPWR VGND sg13cmos5l_buf_1
XFILLER_22_243 VPWR VGND sg13cmos5l_decap_8
Xfanout58 fanout58/X _1843_/X VPWR VGND sg13cmos5l_buf_1
XFILLER_10_416 VPWR VGND sg13cmos5l_decap_8
Xfanout69 _1985_/B _1839_/X VPWR VGND sg13cmos5l_buf_1
XFILLER_22_265 VPWR VGND sg13cmos5l_decap_8
XFILLER_23_799 VPWR VGND sg13cmos5l_decap_8
XFILLER_13_79 VPWR VGND sg13cmos5l_fill_2
Xhold450 _2371_/C _3108_/Q VPWR VGND sg13cmos5l_dlygate4sd3_1
Xhold461 hold461/X _3017_/Q VPWR VGND sg13cmos5l_dlygate4sd3_1
XFILLER_1_114 VPWR VGND sg13cmos5l_decap_8
XFILLER_49_118 VPWR VGND sg13cmos5l_decap_8
XFILLER_38_21 VPWR VGND sg13cmos5l_decap_8
XFILLER_38_54 VPWR VGND sg13cmos5l_fill_1
XFILLER_46_869 VPWR VGND sg13cmos5l_decap_8
XFILLER_14_733 VPWR VGND sg13cmos5l_decap_4
XFILLER_41_552 VPWR VGND sg13cmos5l_decap_4
XFILLER_13_232 VPWR VGND sg13cmos5l_decap_8
XFILLER_14_766 VPWR VGND sg13cmos5l_decap_4
XFILLER_9_203 VPWR VGND sg13cmos5l_decap_8
XFILLER_13_265 VPWR VGND sg13cmos5l_decap_8
XFILLER_14_777 VPWR VGND sg13cmos5l_decap_8
XFILLER_6_921 VPWR VGND sg13cmos5l_decap_8
XFILLER_10_972 VPWR VGND sg13cmos5l_decap_8
XFILLER_5_431 VPWR VGND sg13cmos5l_fill_1
XFILLER_6_998 VPWR VGND sg13cmos5l_decap_8
XFILLER_48_7 VPWR VGND sg13cmos5l_decap_8
XFILLER_1_681 VPWR VGND sg13cmos5l_decap_8
Xclkbuf_5_6__f_clk _3013_/CLK clkbuf_4_3_0_clk/X VPWR VGND sg13cmos5l_buf_8
XFILLER_23_1023 VPWR VGND sg13cmos5l_decap_4
XFILLER_49_674 VPWR VGND sg13cmos5l_decap_8
X_3020_ _3020_/Q _3135_/CLK _3020_/D fanout168/X VPWR VGND sg13cmos5l_dfrbpq_1
XFILLER_36_324 VPWR VGND sg13cmos5l_decap_8
XFILLER_45_891 VPWR VGND sg13cmos5l_decap_8
XFILLER_17_593 VPWR VGND sg13cmos5l_decap_8
XFILLER_20_714 VPWR VGND sg13cmos5l_fill_2
XFILLER_32_574 VPWR VGND sg13cmos5l_decap_4
XFILLER_32_585 VPWR VGND sg13cmos5l_decap_8
X_2804_ _2805_/D _2804_/A _2804_/B _2804_/C _2804_/D VPWR VGND sg13cmos5l_nand4_1
XFILLER_20_769 VPWR VGND sg13cmos5l_decap_8
XFILLER_30_1016 VPWR VGND sg13cmos5l_decap_8
X_2735_ _2735_/Y _2741_/C _2734_/Y _2856_/B VPWR VGND sg13cmos5l_o21ai_1
XFILLER_8_280 VPWR VGND sg13cmos5l_decap_8
XFILLER_30_1027 VPWR VGND sg13cmos5l_fill_2
X_2666_ _2666_/X _2660_/Y _2664_/Y _2665_/Y VPWR VGND sg13cmos5l_a21o_1
X_1617_ _1617_/Y _1705_/C _1617_/B VPWR VGND sg13cmos5l_nand2_1
X_2597_ _2598_/D _2605_/B _2602_/A _2597_/C VPWR VGND sg13cmos5l_nand3b_1
X_1548_ _1567_/B _1583_/A _1744_/C _1547_/A VPWR VGND sg13cmos5l_a21o_1
XFILLER_8_1028 VPWR VGND sg13cmos5l_fill_1
X_1479_ _1539_/B _2605_/A VPWR VGND sg13cmos5l_inv_1
XFILLER_39_184 VPWR VGND sg13cmos5l_decap_4
XFILLER_27_313 VPWR VGND sg13cmos5l_decap_8
XFILLER_36_880 VPWR VGND sg13cmos5l_decap_8
XFILLER_11_725 VPWR VGND sg13cmos5l_decap_8
XFILLER_10_202 VPWR VGND sg13cmos5l_decap_4
XFILLER_40_88 VPWR VGND sg13cmos5l_decap_8
XFILLER_3_924 VPWR VGND sg13cmos5l_decap_8
XFILLER_2_412 VPWR VGND sg13cmos5l_decap_8
XFILLER_46_1023 VPWR VGND sg13cmos5l_decap_4
Xhold280 _2978_/D _2487_/Y VPWR VGND sg13cmos5l_dlygate4sd3_1
XFILLER_49_64 VPWR VGND sg13cmos5l_decap_8
Xhold291 _2494_/A _3002_/Q VPWR VGND sg13cmos5l_dlygate4sd3_1
XFILLER_2_467 VPWR VGND sg13cmos5l_decap_8
XFILLER_19_814 VPWR VGND sg13cmos5l_fill_1
XFILLER_46_644 VPWR VGND sg13cmos5l_fill_2
XFILLER_45_121 VPWR VGND sg13cmos5l_decap_8
XFILLER_18_357 VPWR VGND sg13cmos5l_decap_8
XFILLER_46_688 VPWR VGND sg13cmos5l_decap_8
XFILLER_33_327 VPWR VGND sg13cmos5l_fill_1
XFILLER_42_850 VPWR VGND sg13cmos5l_fill_1
XFILLER_26_390 VPWR VGND sg13cmos5l_decap_8
XFILLER_41_382 VPWR VGND sg13cmos5l_decap_8
X_2520_ _2520_/Y _2960_/A _2531_/A _2520_/C _2531_/C VPWR VGND sg13cmos5l_nor4_1
XFILLER_6_795 VPWR VGND sg13cmos5l_decap_8
XFILLER_5_272 VPWR VGND sg13cmos5l_decap_8
X_2451_ _2451_/Y _2472_/B _2450_/Y _2448_/Y VPWR VGND sg13cmos5l_a21oi_1
X_2382_ _2382_/Y _2393_/A _2382_/B _2384_/B VPWR VGND sg13cmos5l_nor3_1
X_3003_ _3003_/Q clkload2/A _3003_/D fanout155/X VPWR VGND sg13cmos5l_dfrbpq_1
XFILLER_37_633 VPWR VGND sg13cmos5l_decap_8
XFILLER_37_611 VPWR VGND sg13cmos5l_decap_4
XFILLER_36_110 VPWR VGND sg13cmos5l_fill_2
XFILLER_37_688 VPWR VGND sg13cmos5l_decap_8
XFILLER_18_880 VPWR VGND sg13cmos5l_decap_8
XFILLER_33_872 VPWR VGND sg13cmos5l_decap_8
XFILLER_20_555 VPWR VGND sg13cmos5l_fill_2
X_2718_ _2718_/Y _2740_/A _2726_/C VPWR VGND sg13cmos5l_nor2_1
XFILLER_10_25 VPWR VGND sg13cmos5l_decap_4
X_2649_ _2649_/Y _2649_/A _2649_/B VPWR VGND sg13cmos5l_nor2_1
XFILLER_10_58 VPWR VGND sg13cmos5l_fill_2
XFILLER_28_600 VPWR VGND sg13cmos5l_fill_2
XFILLER_28_622 VPWR VGND sg13cmos5l_decap_8
XFILLER_43_603 VPWR VGND sg13cmos5l_fill_1
XFILLER_28_688 VPWR VGND sg13cmos5l_decap_4
XFILLER_35_44 VPWR VGND sg13cmos5l_decap_8
XFILLER_15_338 VPWR VGND sg13cmos5l_decap_8
XFILLER_23_360 VPWR VGND sg13cmos5l_decap_8
XFILLER_23_371 VPWR VGND sg13cmos5l_fill_2
XFILLER_23_393 VPWR VGND sg13cmos5l_decap_8
XFILLER_3_721 VPWR VGND sg13cmos5l_decap_8
XFILLER_3_798 VPWR VGND sg13cmos5l_decap_8
XFILLER_2_242 VPWR VGND sg13cmos5l_fill_1
XFILLER_2_275 VPWR VGND sg13cmos5l_decap_8
XFILLER_19_600 VPWR VGND sg13cmos5l_decap_4
XFILLER_20_1015 VPWR VGND sg13cmos5l_decap_8
XFILLER_47_986 VPWR VGND sg13cmos5l_decap_8
XFILLER_19_688 VPWR VGND sg13cmos5l_decap_4
XFILLER_34_614 VPWR VGND sg13cmos5l_decap_8
XFILLER_18_187 VPWR VGND sg13cmos5l_decap_8
XFILLER_34_647 VPWR VGND sg13cmos5l_decap_8
X_1951_ _1952_/D _2308_/B _2149_/B VPWR VGND sg13cmos5l_or2_1
XFILLER_30_820 VPWR VGND sg13cmos5l_decap_8
X_1882_ _1882_/Y _2204_/A _1877_/Y _1881_/Y VPWR VGND sg13cmos5l_o21ai_1
XFILLER_30_897 VPWR VGND sg13cmos5l_decap_8
X_2503_ _2531_/A _2503_/A _2503_/B _2510_/C _2515_/C VPWR VGND sg13cmos5l_nor4_1
XFILLER_6_581 VPWR VGND sg13cmos5l_decap_8
X_2434_ _2435_/A _2432_/A _2436_/B _2433_/Y VPWR VGND sg13cmos5l_o21ai_1
XFILLER_37_0 VPWR VGND sg13cmos5l_decap_4
X_2365_ _3132_/D _2365_/A _2365_/B VPWR VGND sg13cmos5l_nor2_1
X_2296_ _2296_/Y _1961_/Y _2285_/B _2097_/B _2300_/A _2295_/Y VPWR VGND sg13cmos5l_a221oi_1
XFILLER_38_953 VPWR VGND sg13cmos5l_decap_8
XFILLER_37_430 VPWR VGND sg13cmos5l_decap_4
XFILLER_2_81 VPWR VGND sg13cmos5l_decap_8
XFILLER_37_496 VPWR VGND sg13cmos5l_decap_4
XFILLER_12_319 VPWR VGND sg13cmos5l_fill_1
XFILLER_24_179 VPWR VGND sg13cmos5l_decap_8
XFILLER_32_190 VPWR VGND sg13cmos5l_fill_2
XFILLER_20_385 VPWR VGND sg13cmos5l_decap_8
XFILLER_20_396 VPWR VGND sg13cmos5l_fill_2
XFILLER_4_529 VPWR VGND sg13cmos5l_decap_4
XFILLER_43_1004 VPWR VGND sg13cmos5l_decap_8
XFILLER_0_768 VPWR VGND sg13cmos5l_decap_8
XFILLER_29_986 VPWR VGND sg13cmos5l_decap_8
XFILLER_44_967 VPWR VGND sg13cmos5l_decap_8
XFILLER_43_411 VPWR VGND sg13cmos5l_decap_4
XFILLER_28_496 VPWR VGND sg13cmos5l_decap_8
XFILLER_16_669 VPWR VGND sg13cmos5l_decap_8
XFILLER_43_488 VPWR VGND sg13cmos5l_decap_8
XFILLER_8_802 VPWR VGND sg13cmos5l_decap_8
XFILLER_12_853 VPWR VGND sg13cmos5l_decap_8
XFILLER_11_352 VPWR VGND sg13cmos5l_fill_2
XFILLER_11_374 VPWR VGND sg13cmos5l_decap_8
XFILLER_8_879 VPWR VGND sg13cmos5l_decap_8
Xclkbuf_5_31__f_clk _3060_/CLK clkbuf_4_15_0_clk/X VPWR VGND sg13cmos5l_buf_8
XFILLER_3_573 VPWR VGND sg13cmos5l_decap_8
X_2150_ _2150_/Y _2311_/B _2148_/Y _2149_/Y _2076_/A _2076_/B VPWR VGND sg13cmos5l_a221oi_1
X_2081_ _2082_/C _2081_/A _2081_/B VPWR VGND sg13cmos5l_and2_1
XFILLER_35_901 VPWR VGND sg13cmos5l_decap_8
XFILLER_19_474 VPWR VGND sg13cmos5l_fill_2
XFILLER_46_271 VPWR VGND sg13cmos5l_decap_8
XFILLER_35_978 VPWR VGND sg13cmos5l_decap_8
XFILLER_22_617 VPWR VGND sg13cmos5l_fill_2
X_2983_ _2983_/Q _3085_/CLK _2983_/D fanout163/X VPWR VGND sg13cmos5l_dfrbpq_1
XFILLER_34_499 VPWR VGND sg13cmos5l_decap_8
XFILLER_14_190 VPWR VGND sg13cmos5l_fill_1
X_1934_ _2003_/B _2113_/A _2267_/A VPWR VGND sg13cmos5l_nand2_1
X_1865_ _2308_/D _1865_/A _2259_/A VPWR VGND sg13cmos5l_nand2_1
X_1796_ _1807_/B _2916_/A _1796_/B VPWR VGND sg13cmos5l_nand2b_1
X_2417_ _2419_/A _2417_/A _2417_/B VPWR VGND sg13cmos5l_and2_1
X_2348_ _2349_/C _3021_/Q _2599_/A _2348_/C _2348_/D VPWR VGND sg13cmos5l_nand4_1
XFILLER_29_227 VPWR VGND sg13cmos5l_decap_8
X_2279_ _2280_/D _2279_/A _2229_/A VPWR VGND sg13cmos5l_nor2b_1
XFILLER_25_400 VPWR VGND sg13cmos5l_decap_4
XFILLER_26_923 VPWR VGND sg13cmos5l_decap_8
XFILLER_37_293 VPWR VGND sg13cmos5l_decap_8
XFILLER_16_57 VPWR VGND sg13cmos5l_decap_8
XFILLER_16_68 VPWR VGND sg13cmos5l_fill_2
XFILLER_41_959 VPWR VGND sg13cmos5l_decap_8
XFILLER_16_79 VPWR VGND sg13cmos5l_decap_8
XFILLER_40_447 VPWR VGND sg13cmos5l_decap_4
XFILLER_21_650 VPWR VGND sg13cmos5l_decap_8
XFILLER_20_182 VPWR VGND sg13cmos5l_decap_8
XFILLER_10_1014 VPWR VGND sg13cmos5l_decap_8
XFILLER_0_510 VPWR VGND sg13cmos5l_decap_8
XFILLER_17_956 VPWR VGND sg13cmos5l_decap_8
XFILLER_29_794 VPWR VGND sg13cmos5l_decap_4
XFILLER_44_753 VPWR VGND sg13cmos5l_decap_8
XFILLER_43_230 VPWR VGND sg13cmos5l_decap_8
XFILLER_43_285 VPWR VGND sg13cmos5l_decap_8
XFILLER_16_488 VPWR VGND sg13cmos5l_decap_8
XFILLER_16_499 VPWR VGND sg13cmos5l_fill_2
XFILLER_32_948 VPWR VGND sg13cmos5l_decap_8
XFILLER_43_296 VPWR VGND sg13cmos5l_decap_8
XFILLER_8_654 VPWR VGND sg13cmos5l_fill_2
XFILLER_11_171 VPWR VGND sg13cmos5l_fill_1
XFILLER_8_676 VPWR VGND sg13cmos5l_decap_8
X_1650_ _1676_/A _1705_/B _1581_/A _1732_/B _1648_/Y _1705_/C VPWR VGND sg13cmos5l_a221oi_1
X_1581_ _1581_/Y _1581_/A _1612_/B VPWR VGND sg13cmos5l_nor2b_1
XFILLER_4_860 VPWR VGND sg13cmos5l_decap_8
XFILLER_26_1021 VPWR VGND sg13cmos5l_decap_8
X_2202_ _2202_/Y _2240_/A _2202_/B _2202_/C VPWR VGND sg13cmos5l_nor3_1
X_2133_ _2133_/Y _2130_/Y _2132_/Y _2322_/A VPWR VGND sg13cmos5l_o21ai_1
XFILLER_26_219 VPWR VGND sg13cmos5l_decap_8
XFILLER_35_742 VPWR VGND sg13cmos5l_fill_1
X_2064_ _2064_/Y _2074_/A _2063_/Y _2317_/A VPWR VGND sg13cmos5l_a21oi_1
XFILLER_35_786 VPWR VGND sg13cmos5l_fill_2
XFILLER_34_274 VPWR VGND sg13cmos5l_fill_2
XFILLER_10_609 VPWR VGND sg13cmos5l_decap_8
X_2966_ _2966_/Y _2966_/A _2966_/B VPWR VGND sg13cmos5l_xnor2_1
X_1917_ _2173_/A _2108_/A _1917_/B VPWR VGND sg13cmos5l_nor2_1
X_2897_ _2897_/X _2895_/B _2902_/B _2896_/Y VPWR VGND sg13cmos5l_a21o_1
XFILLER_30_491 VPWR VGND sg13cmos5l_fill_1
X_1848_ _1848_/Y _1845_/A _1836_/C _1847_/Y VPWR VGND sg13cmos5l_a21oi_1
X_1779_ _1780_/B _2473_/A _2442_/C VPWR VGND sg13cmos5l_nor2_1
XFILLER_41_701 VPWR VGND sg13cmos5l_decap_4
XFILLER_25_241 VPWR VGND sg13cmos5l_fill_2
XFILLER_41_723 VPWR VGND sg13cmos5l_fill_1
XFILLER_13_414 VPWR VGND sg13cmos5l_decap_8
XFILLER_14_926 VPWR VGND sg13cmos5l_decap_8
XFILLER_43_99 VPWR VGND sg13cmos5l_decap_8
XFILLER_40_277 VPWR VGND sg13cmos5l_fill_1
XFILLER_22_981 VPWR VGND sg13cmos5l_decap_8
XFILLER_5_657 VPWR VGND sg13cmos5l_decap_8
XFILLER_4_101 VPWR VGND sg13cmos5l_fill_2
XFILLER_49_1021 VPWR VGND sg13cmos5l_decap_8
XFILLER_4_156 VPWR VGND sg13cmos5l_fill_1
XFILLER_4_178 VPWR VGND sg13cmos5l_decap_8
XFILLER_1_863 VPWR VGND sg13cmos5l_decap_8
XFILLER_49_867 VPWR VGND sg13cmos5l_decap_8
XFILLER_0_384 VPWR VGND sg13cmos5l_fill_2
XFILLER_48_399 VPWR VGND sg13cmos5l_decap_8
XFILLER_31_200 VPWR VGND sg13cmos5l_decap_8
X_2820_ _2820_/Y _2821_/A _2821_/B VPWR VGND sg13cmos5l_nor2_1
XFILLER_13_981 VPWR VGND sg13cmos5l_decap_8
X_2751_ _2751_/Y _2757_/B _2750_/Y _2645_/Y VPWR VGND sg13cmos5l_o21ai_1
XFILLER_12_491 VPWR VGND sg13cmos5l_decap_8
X_2682_ _2682_/Y _2746_/A _2682_/B VPWR VGND sg13cmos5l_nand2_1
XFILLER_9_996 VPWR VGND sg13cmos5l_decap_8
X_1702_ _1702_/Y _1676_/Y _1701_/Y _1488_/Y VPWR VGND sg13cmos5l_o21ai_1
XFILLER_8_495 VPWR VGND sg13cmos5l_decap_8
X_1633_ _1739_/B _1698_/A _1633_/B VPWR VGND sg13cmos5l_nand2_1
X_1564_ _1599_/A _3130_/Q _1852_/B VPWR VGND sg13cmos5l_xnor2_1
X_1495_ _1495_/Y _2402_/A VPWR VGND sg13cmos5l_inv_1
X_2116_ _2116_/Y _2116_/A _2116_/B _2116_/C VPWR VGND sg13cmos5l_nand3_1
X_3096_ _3096_/Q _3099_/CLK _3096_/D fanout152/X VPWR VGND sg13cmos5l_dfrbpq_1
X_2047_ _2050_/C _2178_/A _2047_/B _2047_/C VPWR VGND sg13cmos5l_nand3b_1
Xfanout26 _2730_/B1 _2648_/A VPWR VGND sg13cmos5l_buf_1
Xfanout37 _2311_/A _1889_/Y VPWR VGND sg13cmos5l_buf_1
Xfanout15 _1633_/B _1573_/Y VPWR VGND sg13cmos5l_buf_1
XFILLER_22_222 VPWR VGND sg13cmos5l_decap_8
XFILLER_23_745 VPWR VGND sg13cmos5l_decap_8
Xfanout48 _2147_/A _1848_/Y VPWR VGND sg13cmos5l_buf_1
Xfanout59 _2266_/A _2186_/B VPWR VGND sg13cmos5l_buf_1
XFILLER_11_929 VPWR VGND sg13cmos5l_decap_8
X_2949_ _2952_/C _3041_/Q _2949_/B _2949_/C _2949_/D VPWR VGND sg13cmos5l_nor4_1
XFILLER_13_25 VPWR VGND sg13cmos5l_decap_8
Xhold440 _3085_/D _2962_/Y VPWR VGND sg13cmos5l_dlygate4sd3_1
Xhold462 hold462/X _3021_/Q VPWR VGND sg13cmos5l_dlygate4sd3_1
Xhold451 _2396_/A _2398_/A VPWR VGND sg13cmos5l_dlygate4sd3_1
XFILLER_2_649 VPWR VGND sg13cmos5l_decap_8
XFILLER_1_159 VPWR VGND sg13cmos5l_decap_8
XFILLER_18_517 VPWR VGND sg13cmos5l_fill_1
XFILLER_18_528 VPWR VGND sg13cmos5l_fill_2
XFILLER_45_369 VPWR VGND sg13cmos5l_decap_8
XFILLER_45_347 VPWR VGND sg13cmos5l_fill_2
XFILLER_14_701 VPWR VGND sg13cmos5l_decap_8
XFILLER_26_561 VPWR VGND sg13cmos5l_decap_8
XFILLER_41_531 VPWR VGND sg13cmos5l_decap_8
XFILLER_13_211 VPWR VGND sg13cmos5l_decap_8
XFILLER_6_900 VPWR VGND sg13cmos5l_decap_8
XFILLER_10_951 VPWR VGND sg13cmos5l_decap_8
XFILLER_6_977 VPWR VGND sg13cmos5l_decap_8
XFILLER_5_465 VPWR VGND sg13cmos5l_decap_8
XFILLER_1_660 VPWR VGND sg13cmos5l_decap_8
XFILLER_23_1002 VPWR VGND sg13cmos5l_decap_8
XFILLER_49_653 VPWR VGND sg13cmos5l_decap_8
XFILLER_36_369 VPWR VGND sg13cmos5l_decap_4
XFILLER_45_870 VPWR VGND sg13cmos5l_decap_8
XFILLER_17_572 VPWR VGND sg13cmos5l_decap_8
X_2803_ _2805_/C _2803_/A _2803_/B _2803_/C _2803_/D VPWR VGND sg13cmos5l_nand4_1
X_2734_ _2734_/Y _3038_/Q _2749_/B _2728_/Y VPWR VGND sg13cmos5l_a21oi_1
XFILLER_9_793 VPWR VGND sg13cmos5l_decap_8
X_2665_ _2665_/Y _2660_/Y _2664_/Y _2746_/A VPWR VGND sg13cmos5l_o21ai_1
X_2596_ _2598_/C _2596_/A _2612_/A _2596_/C VPWR VGND sg13cmos5l_nand3_1
X_1616_ _1617_/B _1613_/Y _1615_/Y _1631_/B VPWR VGND sg13cmos5l_o21ai_1
XFILLER_5_81 VPWR VGND sg13cmos5l_decap_8
X_1547_ _1583_/B _1547_/A _1744_/C VPWR VGND sg13cmos5l_nor2b_1
X_1478_ _2131_/A _2331_/A VPWR VGND sg13cmos5l_inv_1
XFILLER_39_163 VPWR VGND sg13cmos5l_decap_8
XFILLER_27_369 VPWR VGND sg13cmos5l_decap_8
X_3079_ _3079_/Q _3129_/CLK _3079_/D fanout174/X VPWR VGND sg13cmos5l_dfrbpq_1
XFILLER_35_391 VPWR VGND sg13cmos5l_decap_8
XFILLER_23_542 VPWR VGND sg13cmos5l_decap_8
XFILLER_11_704 VPWR VGND sg13cmos5l_decap_8
XFILLER_10_258 VPWR VGND sg13cmos5l_decap_8
XFILLER_6_218 VPWR VGND sg13cmos5l_decap_8
XFILLER_40_67 VPWR VGND sg13cmos5l_decap_8
XFILLER_3_903 VPWR VGND sg13cmos5l_decap_8
XFILLER_46_1002 VPWR VGND sg13cmos5l_decap_8
Xhold270 _2819_/B _2817_/Y VPWR VGND sg13cmos5l_dlygate4sd3_1
XFILLER_6_4 VPWR VGND sg13cmos5l_decap_4
XFILLER_2_446 VPWR VGND sg13cmos5l_decap_8
XFILLER_49_43 VPWR VGND sg13cmos5l_decap_8
Xhold292 _3002_/D _2582_/X VPWR VGND sg13cmos5l_dlygate4sd3_1
Xhold281 _1513_/A _3079_/Q VPWR VGND sg13cmos5l_dlygate4sd3_1
XFILLER_46_623 VPWR VGND sg13cmos5l_decap_8
XFILLER_45_111 VPWR VGND sg13cmos5l_fill_2
XFILLER_46_667 VPWR VGND sg13cmos5l_decap_8
XFILLER_18_336 VPWR VGND sg13cmos5l_decap_8
XFILLER_45_177 VPWR VGND sg13cmos5l_decap_8
XFILLER_14_520 VPWR VGND sg13cmos5l_decap_8
XFILLER_27_892 VPWR VGND sg13cmos5l_decap_8
XFILLER_14_564 VPWR VGND sg13cmos5l_decap_8
XFILLER_42_895 VPWR VGND sg13cmos5l_decap_4
XFILLER_41_372 VPWR VGND sg13cmos5l_fill_1
XFILLER_10_781 VPWR VGND sg13cmos5l_fill_2
XFILLER_6_774 VPWR VGND sg13cmos5l_decap_8
XFILLER_5_251 VPWR VGND sg13cmos5l_decap_8
X_2450_ _2450_/Y _2970_/Q _2459_/A _2446_/B _2449_/Y VPWR VGND sg13cmos5l_a22oi_1
X_2381_ _2384_/B _2381_/A _2381_/B VPWR VGND sg13cmos5l_and2_1
XFILLER_49_494 VPWR VGND sg13cmos5l_decap_8
XFILLER_49_483 VPWR VGND sg13cmos5l_fill_2
X_3002_ _3002_/Q _3010_/CLK _3002_/D fanout157/X VPWR VGND sg13cmos5l_dfrbpq_1
XFILLER_37_667 VPWR VGND sg13cmos5l_decap_8
XFILLER_36_122 VPWR VGND sg13cmos5l_decap_8
XFILLER_36_155 VPWR VGND sg13cmos5l_decap_4
XFILLER_32_350 VPWR VGND sg13cmos5l_decap_4
XFILLER_33_851 VPWR VGND sg13cmos5l_decap_8
XFILLER_32_383 VPWR VGND sg13cmos5l_decap_4
X_2717_ _2726_/C _3037_/Q _2717_/B VPWR VGND sg13cmos5l_and2_1
X_2648_ _2649_/B _2648_/A _2648_/B VPWR VGND sg13cmos5l_nor2_1
X_2579_ _2579_/X _3008_/Q _2509_/B _2582_/S VPWR VGND sg13cmos5l_mux2_1
XFILLER_28_667 VPWR VGND sg13cmos5l_decap_8
XFILLER_43_626 VPWR VGND sg13cmos5l_decap_8
XFILLER_15_317 VPWR VGND sg13cmos5l_decap_4
XFILLER_27_155 VPWR VGND sg13cmos5l_decap_8
XFILLER_42_136 VPWR VGND sg13cmos5l_decap_8
XFILLER_24_895 VPWR VGND sg13cmos5l_decap_8
XFILLER_13_1023 VPWR VGND sg13cmos5l_decap_4
XFILLER_3_700 VPWR VGND sg13cmos5l_decap_8
XFILLER_3_777 VPWR VGND sg13cmos5l_decap_8
XFILLER_2_254 VPWR VGND sg13cmos5l_decap_8
XFILLER_38_409 VPWR VGND sg13cmos5l_fill_2
XFILLER_47_965 VPWR VGND sg13cmos5l_decap_8
XFILLER_19_667 VPWR VGND sg13cmos5l_decap_4
XFILLER_33_136 VPWR VGND sg13cmos5l_decap_8
XFILLER_42_670 VPWR VGND sg13cmos5l_decap_4
XFILLER_14_372 VPWR VGND sg13cmos5l_decap_4
XFILLER_14_383 VPWR VGND sg13cmos5l_decap_4
X_1950_ _2135_/B _2057_/B _2149_/B VPWR VGND sg13cmos5l_nor2_1
X_1881_ _1881_/Y _2148_/A _1881_/B VPWR VGND sg13cmos5l_nor2_1
XFILLER_14_394 VPWR VGND sg13cmos5l_decap_8
XFILLER_30_876 VPWR VGND sg13cmos5l_decap_8
X_2502_ _2515_/C _2509_/B _2509_/C _2509_/A VPWR VGND sg13cmos5l_nand3b_1
X_2433_ _2433_/Y _2433_/A _2437_/B VPWR VGND sg13cmos5l_nor2b_1
X_2364_ _3135_/D _2367_/A _2368_/A _2365_/A VPWR VGND sg13cmos5l_a21oi_1
XFILLER_29_409 VPWR VGND sg13cmos5l_decap_8
XFILLER_38_932 VPWR VGND sg13cmos5l_decap_8
X_2295_ _2295_/Y _2300_/B _2294_/Y _2300_/A VPWR VGND sg13cmos5l_a21oi_1
XFILLER_37_486 VPWR VGND sg13cmos5l_fill_2
XFILLER_24_125 VPWR VGND sg13cmos5l_fill_2
XFILLER_25_659 VPWR VGND sg13cmos5l_decap_8
XFILLER_40_607 VPWR VGND sg13cmos5l_fill_1
XFILLER_24_158 VPWR VGND sg13cmos5l_decap_8
XFILLER_40_629 VPWR VGND sg13cmos5l_fill_1
XFILLER_21_821 VPWR VGND sg13cmos5l_fill_1
XFILLER_33_692 VPWR VGND sg13cmos5l_decap_8
XFILLER_20_353 VPWR VGND sg13cmos5l_decap_8
XFILLER_21_876 VPWR VGND sg13cmos5l_decap_4
XFILLER_0_747 VPWR VGND sg13cmos5l_decap_8
XFILLER_28_431 VPWR VGND sg13cmos5l_decap_8
XFILLER_29_965 VPWR VGND sg13cmos5l_decap_8
XFILLER_46_55 VPWR VGND sg13cmos5l_decap_8
XFILLER_16_615 VPWR VGND sg13cmos5l_decap_4
XFILLER_44_946 VPWR VGND sg13cmos5l_decap_8
XFILLER_15_169 VPWR VGND sg13cmos5l_decap_4
XFILLER_24_670 VPWR VGND sg13cmos5l_fill_2
XFILLER_12_832 VPWR VGND sg13cmos5l_decap_8
XFILLER_12_898 VPWR VGND sg13cmos5l_decap_8
XFILLER_8_858 VPWR VGND sg13cmos5l_decap_8
XFILLER_3_552 VPWR VGND sg13cmos5l_decap_8
Xclkbuf_4_9_0_clk clkbuf_4_9_0_clk/X clkbuf_0_clk/X VPWR VGND sg13cmos5l_buf_8
XFILLER_4_1021 VPWR VGND sg13cmos5l_decap_8
X_2080_ _2081_/B _2221_/A _1913_/B _2076_/B VPWR VGND sg13cmos5l_a21oi_1
XFILLER_19_442 VPWR VGND sg13cmos5l_decap_8
XFILLER_46_250 VPWR VGND sg13cmos5l_decap_8
XFILLER_35_957 VPWR VGND sg13cmos5l_decap_8
X_2982_ _2982_/Q _3036_/CLK _2982_/D fanout163/X VPWR VGND sg13cmos5l_dfrbpq_1
XFILLER_43_990 VPWR VGND sg13cmos5l_decap_8
XFILLER_21_106 VPWR VGND sg13cmos5l_decap_8
XFILLER_34_478 VPWR VGND sg13cmos5l_decap_8
XFILLER_14_180 VPWR VGND sg13cmos5l_fill_2
X_1933_ _2054_/B _2268_/A _2251_/A VPWR VGND sg13cmos5l_nor2_1
X_1864_ _2011_/D _1865_/A _2259_/A VPWR VGND sg13cmos5l_and2_1
X_1795_ _1812_/B _2674_/A _2686_/B _3066_/Q VPWR VGND sg13cmos5l_a21o_1
XFILLER_6_390 VPWR VGND sg13cmos5l_fill_2
X_2416_ _3111_/D _2417_/B _2415_/Y VPWR VGND sg13cmos5l_nor2b_1
X_2347_ _2348_/D _2370_/B _2372_/B VPWR VGND sg13cmos5l_nor2_1
XFILLER_29_206 VPWR VGND sg13cmos5l_decap_8
X_2278_ _2279_/A _1890_/Y _2029_/Y _2054_/B VPWR VGND sg13cmos5l_o21ai_1
XFILLER_26_979 VPWR VGND sg13cmos5l_decap_8
XFILLER_41_938 VPWR VGND sg13cmos5l_decap_8
XFILLER_12_117 VPWR VGND sg13cmos5l_fill_2
XFILLER_32_24 VPWR VGND sg13cmos5l_decap_8
XFILLER_20_161 VPWR VGND sg13cmos5l_decap_8
XFILLER_5_839 VPWR VGND sg13cmos5l_decap_8
XFILLER_4_316 VPWR VGND sg13cmos5l_decap_8
XFILLER_20_194 VPWR VGND sg13cmos5l_decap_8
XFILLER_0_566 VPWR VGND sg13cmos5l_decap_4
XFILLER_29_773 VPWR VGND sg13cmos5l_decap_8
XFILLER_16_423 VPWR VGND sg13cmos5l_decap_8
XFILLER_17_935 VPWR VGND sg13cmos5l_decap_8
XFILLER_16_434 VPWR VGND sg13cmos5l_fill_2
XFILLER_43_264 VPWR VGND sg13cmos5l_decap_8
XFILLER_32_927 VPWR VGND sg13cmos5l_decap_8
XFILLER_40_982 VPWR VGND sg13cmos5l_decap_8
XFILLER_11_150 VPWR VGND sg13cmos5l_decap_8
XFILLER_12_651 VPWR VGND sg13cmos5l_decap_4
XFILLER_11_183 VPWR VGND sg13cmos5l_decap_8
XFILLER_7_165 VPWR VGND sg13cmos5l_decap_8
XFILLER_7_143 VPWR VGND sg13cmos5l_fill_2
X_1580_ _1612_/B _1646_/B _1633_/B _1632_/A _3131_/D VPWR VGND sg13cmos5l_nand4_1
XFILLER_26_1000 VPWR VGND sg13cmos5l_decap_8
X_2201_ _2201_/Y _2300_/B _2201_/B VPWR VGND sg13cmos5l_nor2_1
XFILLER_21_4 VPWR VGND sg13cmos5l_fill_2
XFILLER_39_559 VPWR VGND sg13cmos5l_decap_8
X_2132_ _2132_/Y _2294_/A _2241_/A _2132_/C VPWR VGND sg13cmos5l_nand3_1
XFILLER_35_732 VPWR VGND sg13cmos5l_fill_2
X_2063_ _2063_/Y _2063_/A _2063_/B VPWR VGND sg13cmos5l_nand2_1
XFILLER_34_242 VPWR VGND sg13cmos5l_fill_1
XFILLER_22_459 VPWR VGND sg13cmos5l_decap_8
X_2965_ _2966_/B _2967_/A _2965_/B VPWR VGND sg13cmos5l_nor2_1
XFILLER_33_1026 VPWR VGND sg13cmos5l_fill_2
X_1916_ _1916_/Y _2294_/A _2074_/A VPWR VGND sg13cmos5l_nor2_1
X_2896_ _2896_/Y _2896_/A _2896_/B _2900_/B VPWR VGND sg13cmos5l_nor3_1
X_1847_ _1847_/Y _2022_/A _1919_/B VPWR VGND sg13cmos5l_xnor2_1
X_1778_ _3156_/A _1861_/A _1778_/B _1844_/A VPWR VGND sg13cmos5l_nor3_1
XFILLER_45_529 VPWR VGND sg13cmos5l_decap_8
XFILLER_38_581 VPWR VGND sg13cmos5l_decap_8
XFILLER_27_57 VPWR VGND sg13cmos5l_decap_8
XFILLER_14_905 VPWR VGND sg13cmos5l_decap_8
XFILLER_25_220 VPWR VGND sg13cmos5l_decap_8
XFILLER_13_404 VPWR VGND sg13cmos5l_decap_4
XFILLER_26_798 VPWR VGND sg13cmos5l_decap_8
XFILLER_40_223 VPWR VGND sg13cmos5l_decap_8
XFILLER_25_297 VPWR VGND sg13cmos5l_decap_8
XFILLER_43_78 VPWR VGND sg13cmos5l_decap_8
XFILLER_22_960 VPWR VGND sg13cmos5l_decap_8
XFILLER_21_492 VPWR VGND sg13cmos5l_decap_4
XFILLER_49_1000 VPWR VGND sg13cmos5l_decap_8
XFILLER_4_113 VPWR VGND sg13cmos5l_fill_2
XFILLER_4_146 VPWR VGND sg13cmos5l_decap_4
XFILLER_1_842 VPWR VGND sg13cmos5l_decap_8
XFILLER_49_846 VPWR VGND sg13cmos5l_decap_8
XFILLER_48_356 VPWR VGND sg13cmos5l_fill_2
XFILLER_1_1024 VPWR VGND sg13cmos5l_decap_4
XFILLER_17_743 VPWR VGND sg13cmos5l_fill_2
XFILLER_17_765 VPWR VGND sg13cmos5l_decap_8
XFILLER_29_592 VPWR VGND sg13cmos5l_decap_8
XFILLER_16_253 VPWR VGND sg13cmos5l_decap_4
XFILLER_16_264 VPWR VGND sg13cmos5l_fill_2
XFILLER_17_90 VPWR VGND sg13cmos5l_decap_8
XFILLER_16_286 VPWR VGND sg13cmos5l_decap_4
XFILLER_13_960 VPWR VGND sg13cmos5l_decap_8
XFILLER_40_790 VPWR VGND sg13cmos5l_decap_8
X_2750_ _2750_/Y _3040_/Q _2749_/B _2744_/A VPWR VGND sg13cmos5l_a21oi_1
XFILLER_12_470 VPWR VGND sg13cmos5l_decap_8
X_2681_ _2682_/B _2681_/A _2681_/B VPWR VGND sg13cmos5l_xnor2_1
XFILLER_8_463 VPWR VGND sg13cmos5l_decap_4
XFILLER_9_975 VPWR VGND sg13cmos5l_decap_8
X_1701_ _1701_/Y _3127_/Q _1701_/B _1701_/C VPWR VGND sg13cmos5l_nor3_1
XFILLER_8_474 VPWR VGND sg13cmos5l_decap_8
X_1632_ _1697_/D _1632_/A _1696_/C VPWR VGND sg13cmos5l_nor2_1
X_1563_ _1581_/A _1681_/A _1693_/A VPWR VGND sg13cmos5l_nor2_1
X_1494_ _2414_/A _2328_/C VPWR VGND sg13cmos5l_inv_1
XFILLER_39_312 VPWR VGND sg13cmos5l_decap_8
XFILLER_39_367 VPWR VGND sg13cmos5l_decap_8
XFILLER_39_389 VPWR VGND sg13cmos5l_decap_8
XFILLER_39_378 VPWR VGND sg13cmos5l_fill_2
X_2115_ _2116_/C _2113_/Y _2114_/Y _2404_/C VPWR VGND sg13cmos5l_o21ai_1
XFILLER_27_529 VPWR VGND sg13cmos5l_fill_2
X_3095_ _3095_/Q _3122_/CLK input3/X fanout152/X VPWR VGND sg13cmos5l_dfrbpq_1
X_2046_ _2047_/B _2308_/A _2311_/A _2266_/B VPWR VGND sg13cmos5l_nand3_1
XFILLER_22_201 VPWR VGND sg13cmos5l_decap_8
Xfanout27 _2648_/A _2747_/A VPWR VGND sg13cmos5l_buf_1
Xfanout38 _2063_/A _2259_/B VPWR VGND sg13cmos5l_buf_1
Xfanout16 _1732_/B _1573_/Y VPWR VGND sg13cmos5l_buf_1
XFILLER_11_908 VPWR VGND sg13cmos5l_decap_8
Xfanout49 _2057_/B _1848_/Y VPWR VGND sg13cmos5l_buf_1
X_2948_ _2949_/D _2948_/A _2948_/B VPWR VGND sg13cmos5l_xnor2_1
X_2879_ _2879_/Y _2881_/A _2879_/B VPWR VGND sg13cmos5l_nand2_1
Xhold430 _2537_/D _3102_/Q VPWR VGND sg13cmos5l_dlygate4sd3_1
Xhold441 hold441/X _3040_/Q VPWR VGND sg13cmos5l_dlygate4sd3_1
XFILLER_8_8 VPWR VGND sg13cmos5l_fill_1
Xhold463 hold463/X _3020_/Q VPWR VGND sg13cmos5l_dlygate4sd3_1
XFILLER_2_628 VPWR VGND sg13cmos5l_decap_8
Xhold452 _3122_/D _2396_/Y VPWR VGND sg13cmos5l_dlygate4sd3_1
XFILLER_26_540 VPWR VGND sg13cmos5l_decap_8
XFILLER_26_584 VPWR VGND sg13cmos5l_decap_4
XFILLER_9_238 VPWR VGND sg13cmos5l_fill_2
XFILLER_10_930 VPWR VGND sg13cmos5l_decap_8
XFILLER_16_1021 VPWR VGND sg13cmos5l_decap_8
XFILLER_6_956 VPWR VGND sg13cmos5l_decap_8
XFILLER_5_488 VPWR VGND sg13cmos5l_decap_8
XFILLER_49_632 VPWR VGND sg13cmos5l_decap_8
XFILLER_0_193 VPWR VGND sg13cmos5l_decap_8
XFILLER_36_359 VPWR VGND sg13cmos5l_fill_1
XFILLER_44_392 VPWR VGND sg13cmos5l_decap_8
XFILLER_32_521 VPWR VGND sg13cmos5l_fill_2
Xheichips26_daftASIC uio_out[0] VPWR VGND sg13cmos5l_tielo
XFILLER_32_554 VPWR VGND sg13cmos5l_fill_1
X_2802_ _2805_/B _2802_/A _2802_/B _2802_/C VPWR VGND sg13cmos5l_nand3_1
X_2733_ _2741_/C _3039_/Q _2749_/B VPWR VGND sg13cmos5l_xnor2_1
XFILLER_9_772 VPWR VGND sg13cmos5l_decap_8
X_2664_ _2664_/Y _2664_/A _2664_/B VPWR VGND sg13cmos5l_xnor2_1
X_2595_ _2595_/Y _1852_/B _2594_/B _2244_/B VPWR VGND sg13cmos5l_a21oi_1
X_1615_ _1615_/Y _1681_/A _1644_/A VPWR VGND sg13cmos5l_nand2_1
X_1546_ _1744_/C _1598_/A _3131_/Q VPWR VGND sg13cmos5l_nand2b_1
XFILLER_5_60 VPWR VGND sg13cmos5l_decap_8
XFILLER_8_1019 VPWR VGND sg13cmos5l_decap_8
X_1477_ _1751_/A _3135_/Q VPWR VGND sg13cmos5l_inv_1
XFILLER_39_142 VPWR VGND sg13cmos5l_decap_8
XFILLER_28_805 VPWR VGND sg13cmos5l_decap_4
XFILLER_43_808 VPWR VGND sg13cmos5l_decap_8
XFILLER_39_197 VPWR VGND sg13cmos5l_decap_8
XFILLER_27_348 VPWR VGND sg13cmos5l_decap_8
XFILLER_39_1010 VPWR VGND sg13cmos5l_decap_8
X_3078_ _3078_/Q clkload7/A _3078_/D fanout173/X VPWR VGND sg13cmos5l_dfrbpq_1
XFILLER_35_370 VPWR VGND sg13cmos5l_decap_8
X_2029_ _2029_/Y _2183_/C _2029_/B _2029_/C VPWR VGND sg13cmos5l_nor3_1
XFILLER_10_215 VPWR VGND sg13cmos5l_fill_1
XFILLER_23_587 VPWR VGND sg13cmos5l_fill_1
XFILLER_49_11 VPWR VGND sg13cmos5l_decap_8
Xhold271 _3051_/D _2819_/Y VPWR VGND sg13cmos5l_dlygate4sd3_1
XFILLER_3_959 VPWR VGND sg13cmos5l_decap_8
XFILLER_2_425 VPWR VGND sg13cmos5l_decap_8
Xhold260 _3117_/D _2382_/Y VPWR VGND sg13cmos5l_dlygate4sd3_1
Xhold282 hold282/X _3003_/Q VPWR VGND sg13cmos5l_dlygate4sd3_1
Xhold293 _1507_/A _3048_/Q VPWR VGND sg13cmos5l_dlygate4sd3_1
XFILLER_49_99 VPWR VGND sg13cmos5l_fill_2
XFILLER_19_805 VPWR VGND sg13cmos5l_decap_8
XFILLER_18_315 VPWR VGND sg13cmos5l_decap_8
XFILLER_46_646 VPWR VGND sg13cmos5l_fill_1
XFILLER_45_156 VPWR VGND sg13cmos5l_decap_8
XFILLER_42_874 VPWR VGND sg13cmos5l_decap_8
XFILLER_14_598 VPWR VGND sg13cmos5l_decap_8
XFILLER_6_753 VPWR VGND sg13cmos5l_decap_8
Xclkbuf_5_14__f_clk _3009_/CLK clkbuf_4_7_0_clk/X VPWR VGND sg13cmos5l_buf_8
XFILLER_30_90 VPWR VGND sg13cmos5l_fill_2
X_2380_ _2380_/Y _2381_/A _2381_/B VPWR VGND sg13cmos5l_nor2_1
XFILLER_2_992 VPWR VGND sg13cmos5l_decap_8
XFILLER_1_480 VPWR VGND sg13cmos5l_decap_4
XFILLER_1_491 VPWR VGND sg13cmos5l_fill_2
XFILLER_49_462 VPWR VGND sg13cmos5l_decap_8
X_3001_ _3001_/Q _3010_/CLK _3001_/D fanout157/X VPWR VGND sg13cmos5l_dfrbpq_1
XFILLER_37_657 VPWR VGND sg13cmos5l_decap_4
XFILLER_24_329 VPWR VGND sg13cmos5l_decap_8
XFILLER_33_830 VPWR VGND sg13cmos5l_decap_4
XFILLER_20_513 VPWR VGND sg13cmos5l_decap_8
XFILLER_20_524 VPWR VGND sg13cmos5l_fill_2
X_2716_ _2740_/A _3037_/Q _2749_/B VPWR VGND sg13cmos5l_nor2_1
X_2647_ _2648_/B _1500_/A _2518_/A _2639_/B VPWR VGND sg13cmos5l_a21oi_1
X_2578_ _2578_/Y _2515_/A _2577_/B _2577_/Y VPWR VGND sg13cmos5l_a21oi_1
XFILLER_0_929 VPWR VGND sg13cmos5l_decap_8
X_1529_ _1530_/D _2973_/Q _1527_/A VPWR VGND sg13cmos5l_nor2b_1
XFILLER_19_25 VPWR VGND sg13cmos5l_decap_4
XFILLER_28_602 VPWR VGND sg13cmos5l_fill_1
XFILLER_28_657 VPWR VGND sg13cmos5l_fill_1
XFILLER_42_104 VPWR VGND sg13cmos5l_fill_1
XFILLER_42_148 VPWR VGND sg13cmos5l_decap_4
XFILLER_24_874 VPWR VGND sg13cmos5l_decap_8
XFILLER_11_502 VPWR VGND sg13cmos5l_decap_4
XFILLER_11_524 VPWR VGND sg13cmos5l_decap_8
XFILLER_11_557 VPWR VGND sg13cmos5l_decap_8
XFILLER_13_1002 VPWR VGND sg13cmos5l_decap_8
XFILLER_3_756 VPWR VGND sg13cmos5l_decap_8
XFILLER_2_233 VPWR VGND sg13cmos5l_decap_8
XFILLER_19_624 VPWR VGND sg13cmos5l_decap_8
XFILLER_47_944 VPWR VGND sg13cmos5l_decap_8
XFILLER_18_112 VPWR VGND sg13cmos5l_decap_8
XFILLER_18_123 VPWR VGND sg13cmos5l_fill_1
XFILLER_18_156 VPWR VGND sg13cmos5l_decap_8
XFILLER_46_498 VPWR VGND sg13cmos5l_decap_8
XFILLER_33_115 VPWR VGND sg13cmos5l_decap_8
XFILLER_14_351 VPWR VGND sg13cmos5l_decap_8
X_1880_ _1881_/B _2186_/B _1966_/B _2267_/A VPWR VGND sg13cmos5l_a21oi_1
XFILLER_30_855 VPWR VGND sg13cmos5l_decap_8
X_2501_ _2516_/A _2995_/Q _2503_/B _2501_/C VPWR VGND sg13cmos5l_nor3_1
X_2432_ _2437_/B _2432_/A _2436_/B VPWR VGND sg13cmos5l_nand2_1
X_2363_ _2365_/B _2367_/A _2368_/A VPWR VGND sg13cmos5l_xnor2_1
XFILLER_38_911 VPWR VGND sg13cmos5l_decap_8
X_2294_ _2294_/Y _2294_/A _2294_/B _2294_/C VPWR VGND sg13cmos5l_nand3_1
XFILLER_38_988 VPWR VGND sg13cmos5l_decap_8
XFILLER_37_465 VPWR VGND sg13cmos5l_decap_8
XFILLER_24_137 VPWR VGND sg13cmos5l_decap_8
XFILLER_36_1013 VPWR VGND sg13cmos5l_decap_8
XFILLER_20_332 VPWR VGND sg13cmos5l_fill_2
XFILLER_21_855 VPWR VGND sg13cmos5l_decap_8
XFILLER_21_899 VPWR VGND sg13cmos5l_decap_8
XFILLER_0_726 VPWR VGND sg13cmos5l_decap_8
XFILLER_46_23 VPWR VGND sg13cmos5l_decap_8
XFILLER_29_944 VPWR VGND sg13cmos5l_decap_8
XFILLER_44_925 VPWR VGND sg13cmos5l_decap_8
XFILLER_43_424 VPWR VGND sg13cmos5l_decap_8
XFILLER_15_104 VPWR VGND sg13cmos5l_fill_1
XFILLER_43_468 VPWR VGND sg13cmos5l_decap_8
XFILLER_43_446 VPWR VGND sg13cmos5l_fill_1
XFILLER_12_811 VPWR VGND sg13cmos5l_fill_2
XFILLER_30_118 VPWR VGND sg13cmos5l_decap_4
XFILLER_11_332 VPWR VGND sg13cmos5l_fill_1
XFILLER_8_837 VPWR VGND sg13cmos5l_decap_8
XFILLER_7_314 VPWR VGND sg13cmos5l_decap_8
XFILLER_12_877 VPWR VGND sg13cmos5l_decap_8
XFILLER_7_347 VPWR VGND sg13cmos5l_decap_4
XFILLER_7_39 VPWR VGND sg13cmos5l_fill_2
XFILLER_11_398 VPWR VGND sg13cmos5l_decap_8
XFILLER_39_708 VPWR VGND sg13cmos5l_fill_2
XFILLER_4_1000 VPWR VGND sg13cmos5l_decap_8
XFILLER_19_421 VPWR VGND sg13cmos5l_decap_8
XFILLER_47_774 VPWR VGND sg13cmos5l_fill_2
XFILLER_47_785 VPWR VGND sg13cmos5l_decap_8
XFILLER_35_936 VPWR VGND sg13cmos5l_decap_8
XFILLER_19_487 VPWR VGND sg13cmos5l_decap_8
XFILLER_34_457 VPWR VGND sg13cmos5l_decap_8
X_2981_ _2981_/Q clkload6/A _2981_/D fanout163/X VPWR VGND sg13cmos5l_dfrbpq_1
XFILLER_22_619 VPWR VGND sg13cmos5l_fill_1
X_1932_ _1932_/Y _1927_/Y _1931_/Y _2210_/A VPWR VGND sg13cmos5l_o21ai_1
XFILLER_30_641 VPWR VGND sg13cmos5l_decap_4
X_1863_ _2259_/A _1861_/A _1862_/B _2244_/A VPWR VGND sg13cmos5l_o21ai_1
X_1794_ _1812_/A _3066_/Q _2674_/A _2686_/B VPWR VGND sg13cmos5l_nand3_1
XFILLER_7_881 VPWR VGND sg13cmos5l_decap_8
XFILLER_6_380 VPWR VGND sg13cmos5l_fill_1
XFILLER_42_0 VPWR VGND sg13cmos5l_fill_2
X_2415_ _2415_/Y _2414_/B _2440_/C _2414_/A VPWR VGND sg13cmos5l_o21ai_1
X_2346_ _2372_/B _2346_/A _2401_/C VPWR VGND sg13cmos5l_nor2_1
X_2277_ _2280_/C _2277_/A _2212_/B VPWR VGND sg13cmos5l_nor2b_1
XFILLER_25_424 VPWR VGND sg13cmos5l_decap_4
XFILLER_26_958 VPWR VGND sg13cmos5l_decap_8
XFILLER_41_917 VPWR VGND sg13cmos5l_decap_8
XFILLER_25_479 VPWR VGND sg13cmos5l_fill_1
XFILLER_34_980 VPWR VGND sg13cmos5l_decap_8
XFILLER_32_14 VPWR VGND sg13cmos5l_fill_1
XFILLER_21_685 VPWR VGND sg13cmos5l_decap_4
XFILLER_21_696 VPWR VGND sg13cmos5l_decap_8
XFILLER_5_818 VPWR VGND sg13cmos5l_decap_8
XFILLER_0_545 VPWR VGND sg13cmos5l_decap_8
XFILLER_17_914 VPWR VGND sg13cmos5l_decap_8
XFILLER_43_243 VPWR VGND sg13cmos5l_decap_8
XFILLER_16_457 VPWR VGND sg13cmos5l_decap_8
XFILLER_32_906 VPWR VGND sg13cmos5l_decap_8
XFILLER_24_490 VPWR VGND sg13cmos5l_decap_4
XFILLER_40_961 VPWR VGND sg13cmos5l_decap_8
XFILLER_8_656 VPWR VGND sg13cmos5l_fill_1
XFILLER_8_623 VPWR VGND sg13cmos5l_fill_2
XFILLER_7_122 VPWR VGND sg13cmos5l_decap_8
XFILLER_11_195 VPWR VGND sg13cmos5l_decap_8
XFILLER_7_199 VPWR VGND sg13cmos5l_decap_8
XFILLER_4_895 VPWR VGND sg13cmos5l_decap_8
XFILLER_3_383 VPWR VGND sg13cmos5l_decap_8
X_2200_ _2201_/B _2190_/C _2118_/Y _2235_/B VPWR VGND sg13cmos5l_a21oi_1
XFILLER_14_4 VPWR VGND sg13cmos5l_decap_8
X_2131_ _2132_/C _2131_/A _2131_/B _2131_/C VPWR VGND sg13cmos5l_nand3_1
X_2062_ _2065_/B _2147_/A _1901_/B _2061_/Y _2308_/A VPWR VGND sg13cmos5l_a22oi_1
XFILLER_47_593 VPWR VGND sg13cmos5l_decap_8
XFILLER_19_273 VPWR VGND sg13cmos5l_decap_4
XFILLER_35_788 VPWR VGND sg13cmos5l_fill_1
XFILLER_23_939 VPWR VGND sg13cmos5l_decap_8
X_2964_ _2964_/X _2964_/A1 _2960_/A _2963_/Y VPWR VGND sg13cmos5l_a21o_1
XFILLER_22_438 VPWR VGND sg13cmos5l_decap_8
X_1915_ _1915_/Y _2108_/A _1915_/B _2038_/B VPWR VGND sg13cmos5l_nand3_1
XFILLER_33_1005 VPWR VGND sg13cmos5l_decap_8
X_2895_ _2900_/B _3073_/Q _2895_/B _2895_/C VPWR VGND sg13cmos5l_and3_1
XFILLER_30_471 VPWR VGND sg13cmos5l_decap_8
XFILLER_31_983 VPWR VGND sg13cmos5l_decap_8
XFILLER_8_93 VPWR VGND sg13cmos5l_decap_8
X_1846_ _1889_/A _2022_/A _1865_/A VPWR VGND sg13cmos5l_xor2_1
X_1777_ _1844_/A _2596_/A _2612_/A VPWR VGND sg13cmos5l_or2_1
X_2329_ _2440_/A _2370_/A _2346_/A VPWR VGND sg13cmos5l_nand2_1
XFILLER_27_25 VPWR VGND sg13cmos5l_fill_2
XFILLER_43_13 VPWR VGND sg13cmos5l_decap_8
XFILLER_40_202 VPWR VGND sg13cmos5l_decap_8
Xclkbuf_4_8_0_clk clkbuf_4_8_0_clk/X clkbuf_0_clk/X VPWR VGND sg13cmos5l_buf_8
XFILLER_43_57 VPWR VGND sg13cmos5l_decap_8
XFILLER_21_471 VPWR VGND sg13cmos5l_decap_8
XFILLER_4_103 VPWR VGND sg13cmos5l_fill_1
XFILLER_4_125 VPWR VGND sg13cmos5l_decap_8
XFILLER_1_821 VPWR VGND sg13cmos5l_decap_8
XFILLER_49_825 VPWR VGND sg13cmos5l_decap_8
XFILLER_0_364 VPWR VGND sg13cmos5l_decap_8
XFILLER_0_397 VPWR VGND sg13cmos5l_decap_8
XFILLER_1_898 VPWR VGND sg13cmos5l_decap_8
XFILLER_1_1003 VPWR VGND sg13cmos5l_decap_8
XFILLER_17_711 VPWR VGND sg13cmos5l_decap_8
XFILLER_17_722 VPWR VGND sg13cmos5l_fill_2
XFILLER_16_232 VPWR VGND sg13cmos5l_decap_8
XFILLER_44_552 VPWR VGND sg13cmos5l_decap_8
XFILLER_32_714 VPWR VGND sg13cmos5l_decap_8
XFILLER_8_420 VPWR VGND sg13cmos5l_decap_4
XFILLER_9_954 VPWR VGND sg13cmos5l_decap_8
X_2680_ _2681_/B _2660_/Y _2664_/Y _2663_/X VPWR VGND sg13cmos5l_a21oi_1
X_1700_ _1701_/C _1740_/A _1695_/Y _1699_/Y VPWR VGND sg13cmos5l_a21oi_1
X_1631_ _1631_/Y _3127_/Q _1631_/B _1631_/C VPWR VGND sg13cmos5l_nand3_1
X_1562_ _1722_/B _1638_/A _1562_/B VPWR VGND sg13cmos5l_nand2_1
X_1493_ _2673_/A _2442_/C VPWR VGND sg13cmos5l_inv_1
XFILLER_4_692 VPWR VGND sg13cmos5l_decap_8
XFILLER_3_180 VPWR VGND sg13cmos5l_decap_4
X_2114_ _2114_/Y _2241_/A _2158_/B _2222_/A VPWR VGND sg13cmos5l_nand3_1
X_3094_ _3094_/Q _3103_/CLK _3094_/D fanout162/X VPWR VGND sg13cmos5l_dfrbpq_1
X_2045_ _2178_/A _2135_/A _2063_/A VPWR VGND sg13cmos5l_and2_1
XFILLER_35_552 VPWR VGND sg13cmos5l_decap_8
XFILLER_23_703 VPWR VGND sg13cmos5l_decap_8
XFILLER_23_714 VPWR VGND sg13cmos5l_fill_1
Xfanout28 _2747_/A _2754_/B VPWR VGND sg13cmos5l_buf_1
Xfanout17 _1698_/A _1722_/B VPWR VGND sg13cmos5l_buf_1
Xfanout39 _2259_/B _1878_/Y VPWR VGND sg13cmos5l_buf_1
XFILLER_10_408 VPWR VGND sg13cmos5l_fill_2
XFILLER_22_257 VPWR VGND sg13cmos5l_fill_2
XFILLER_23_769 VPWR VGND sg13cmos5l_decap_4
X_2947_ _2949_/C _2947_/A _2947_/B VPWR VGND sg13cmos5l_xnor2_1
XFILLER_22_279 VPWR VGND sg13cmos5l_fill_2
XFILLER_31_780 VPWR VGND sg13cmos5l_decap_4
X_2878_ _2878_/Y _2886_/A1 _2877_/Y _2874_/Y VPWR VGND sg13cmos5l_o21ai_1
Xhold420 _2724_/A _3038_/Q VPWR VGND sg13cmos5l_dlygate4sd3_1
X_1829_ _1843_/B _2131_/B _2022_/A _1865_/A VPWR VGND sg13cmos5l_and3_1
Xhold453 hold453/X _3107_/Q VPWR VGND sg13cmos5l_dlygate4sd3_1
XFILLER_2_607 VPWR VGND sg13cmos5l_decap_8
Xhold442 hold442/X _3125_/Q VPWR VGND sg13cmos5l_dlygate4sd3_1
Xhold431 _2756_/A _3042_/Q VPWR VGND sg13cmos5l_dlygate4sd3_1
Xhold464 hold464/X _3122_/Q VPWR VGND sg13cmos5l_dlygate4sd3_1
XFILLER_18_508 VPWR VGND sg13cmos5l_decap_8
XFILLER_39_891 VPWR VGND sg13cmos5l_decap_8
XFILLER_41_511 VPWR VGND sg13cmos5l_fill_1
XFILLER_14_747 VPWR VGND sg13cmos5l_fill_1
XFILLER_13_246 VPWR VGND sg13cmos5l_fill_1
XFILLER_16_1000 VPWR VGND sg13cmos5l_decap_8
XFILLER_41_599 VPWR VGND sg13cmos5l_decap_8
XFILLER_9_217 VPWR VGND sg13cmos5l_decap_8
XFILLER_13_279 VPWR VGND sg13cmos5l_decap_8
XFILLER_6_935 VPWR VGND sg13cmos5l_decap_8
XFILLER_10_986 VPWR VGND sg13cmos5l_decap_8
XFILLER_49_611 VPWR VGND sg13cmos5l_decap_8
XFILLER_0_172 VPWR VGND sg13cmos5l_decap_8
XFILLER_1_695 VPWR VGND sg13cmos5l_decap_8
XFILLER_48_143 VPWR VGND sg13cmos5l_fill_2
XFILLER_48_187 VPWR VGND sg13cmos5l_fill_2
XFILLER_36_338 VPWR VGND sg13cmos5l_decap_4
XFILLER_32_500 VPWR VGND sg13cmos5l_decap_8
XFILLER_44_371 VPWR VGND sg13cmos5l_decap_8
XFILLER_32_533 VPWR VGND sg13cmos5l_decap_8
X_2801_ _2802_/C _2801_/A _2801_/B _2801_/C VPWR VGND sg13cmos5l_nor3_1
XFILLER_20_739 VPWR VGND sg13cmos5l_decap_8
X_2732_ _2732_/Y _2732_/A _2732_/B VPWR VGND sg13cmos5l_nand2_1
XFILLER_9_751 VPWR VGND sg13cmos5l_decap_8
X_2663_ _2663_/X _3032_/Q _2664_/B VPWR VGND sg13cmos5l_and2_1
X_2594_ _3014_/D _2594_/A _2594_/B VPWR VGND sg13cmos5l_xnor2_1
X_1614_ _1644_/A _1816_/A _1693_/A VPWR VGND sg13cmos5l_nor2_1
X_1545_ _1583_/A _1852_/B _3130_/Q VPWR VGND sg13cmos5l_nand2b_1
XFILLER_39_121 VPWR VGND sg13cmos5l_decap_8
XFILLER_27_327 VPWR VGND sg13cmos5l_decap_8
X_3077_ _3077_/Q _3129_/CLK _3077_/D fanout174/X VPWR VGND sg13cmos5l_dfrbpq_1
X_2028_ _2028_/Y _2032_/A _2286_/A _2028_/C _2028_/D VPWR VGND sg13cmos5l_nor4_1
XFILLER_36_894 VPWR VGND sg13cmos5l_decap_8
XFILLER_24_15 VPWR VGND sg13cmos5l_fill_1
XFILLER_11_739 VPWR VGND sg13cmos5l_decap_8
XFILLER_23_599 VPWR VGND sg13cmos5l_decap_8
XFILLER_10_227 VPWR VGND sg13cmos5l_decap_8
XFILLER_10_238 VPWR VGND sg13cmos5l_fill_2
XFILLER_3_938 VPWR VGND sg13cmos5l_decap_8
Xhold250 _2448_/A _2969_/Q VPWR VGND sg13cmos5l_dlygate4sd3_1
Xhold261 _2477_/A _2975_/Q VPWR VGND sg13cmos5l_dlygate4sd3_1
Xhold283 _3003_/D _2583_/X VPWR VGND sg13cmos5l_dlygate4sd3_1
Xhold294 _2811_/B _2809_/Y VPWR VGND sg13cmos5l_dlygate4sd3_1
Xhold272 _2413_/A _3110_/Q VPWR VGND sg13cmos5l_dlygate4sd3_1
XFILLER_49_78 VPWR VGND sg13cmos5l_decap_8
XFILLER_45_135 VPWR VGND sg13cmos5l_decap_8
XFILLER_34_809 VPWR VGND sg13cmos5l_decap_4
XFILLER_26_360 VPWR VGND sg13cmos5l_fill_2
XFILLER_41_341 VPWR VGND sg13cmos5l_decap_8
XFILLER_41_352 VPWR VGND sg13cmos5l_fill_2
XFILLER_14_588 VPWR VGND sg13cmos5l_fill_1
XFILLER_41_396 VPWR VGND sg13cmos5l_decap_8
XFILLER_14_81 VPWR VGND sg13cmos5l_decap_8
XFILLER_6_732 VPWR VGND sg13cmos5l_decap_8
XFILLER_10_783 VPWR VGND sg13cmos5l_fill_1
XFILLER_46_7 VPWR VGND sg13cmos5l_decap_8
XFILLER_5_286 VPWR VGND sg13cmos5l_decap_8
XFILLER_2_971 VPWR VGND sg13cmos5l_decap_8
XFILLER_49_441 VPWR VGND sg13cmos5l_decap_8
XFILLER_49_485 VPWR VGND sg13cmos5l_fill_1
X_3000_ _3000_/Q _3008_/CLK _3000_/D fanout161/X VPWR VGND sg13cmos5l_dfrbpq_1
XFILLER_37_647 VPWR VGND sg13cmos5l_decap_4
XFILLER_18_894 VPWR VGND sg13cmos5l_decap_8
XFILLER_33_886 VPWR VGND sg13cmos5l_decap_8
XFILLER_20_536 VPWR VGND sg13cmos5l_fill_2
XFILLER_32_396 VPWR VGND sg13cmos5l_fill_2
X_2715_ _2715_/Y _2726_/A _2726_/B VPWR VGND sg13cmos5l_nor2_1
X_2646_ _2646_/Y _1500_/A _2518_/A _2648_/A VPWR VGND sg13cmos5l_a21oi_1
XFILLER_10_39 VPWR VGND sg13cmos5l_fill_1
X_2577_ _2577_/Y _2577_/A _2577_/B VPWR VGND sg13cmos5l_nor2_1
XFILLER_0_908 VPWR VGND sg13cmos5l_decap_8
X_1528_ _1530_/C _2975_/Q _2353_/S VPWR VGND sg13cmos5l_nor2b_1
X_3129_ _3129_/Q _3129_/CLK _3129_/D fanout174/X VPWR VGND sg13cmos5l_dfrbpq_1
XFILLER_35_14 VPWR VGND sg13cmos5l_decap_8
XFILLER_35_58 VPWR VGND sg13cmos5l_fill_2
XFILLER_24_853 VPWR VGND sg13cmos5l_decap_8
Xclkbuf_5_20__f_clk _3134_/CLK clkbuf_4_10_0_clk/X VPWR VGND sg13cmos5l_buf_8
XFILLER_3_735 VPWR VGND sg13cmos5l_decap_8
XFILLER_2_212 VPWR VGND sg13cmos5l_decap_8
XFILLER_2_289 VPWR VGND sg13cmos5l_decap_8
XFILLER_47_923 VPWR VGND sg13cmos5l_decap_8
XFILLER_46_477 VPWR VGND sg13cmos5l_decap_4
XFILLER_46_455 VPWR VGND sg13cmos5l_fill_1
XFILLER_18_135 VPWR VGND sg13cmos5l_decap_8
XFILLER_34_628 VPWR VGND sg13cmos5l_fill_2
XFILLER_14_330 VPWR VGND sg13cmos5l_decap_8
XFILLER_15_853 VPWR VGND sg13cmos5l_decap_8
XFILLER_15_886 VPWR VGND sg13cmos5l_decap_8
XFILLER_30_834 VPWR VGND sg13cmos5l_decap_8
X_2500_ _2533_/B _3103_/D _2500_/B _2967_/B VPWR VGND sg13cmos5l_nand3_1
XFILLER_6_595 VPWR VGND sg13cmos5l_decap_8
X_2431_ _2431_/Y _2436_/B _2431_/B VPWR VGND sg13cmos5l_nor2_1
XFILLER_29_1021 VPWR VGND sg13cmos5l_decap_8
X_2362_ _2366_/B _2362_/A _2368_/A VPWR VGND sg13cmos5l_nor2_1
X_2293_ _2326_/A _2323_/C _2292_/Y _2281_/A VPWR VGND sg13cmos5l_o21ai_1
XFILLER_38_901 VPWR VGND sg13cmos5l_fill_1
XFILLER_49_282 VPWR VGND sg13cmos5l_decap_8
XFILLER_38_967 VPWR VGND sg13cmos5l_decap_8
XFILLER_37_488 VPWR VGND sg13cmos5l_fill_1
XFILLER_24_105 VPWR VGND sg13cmos5l_fill_1
XFILLER_33_650 VPWR VGND sg13cmos5l_fill_1
XFILLER_21_834 VPWR VGND sg13cmos5l_decap_8
XFILLER_32_160 VPWR VGND sg13cmos5l_decap_8
XFILLER_0_705 VPWR VGND sg13cmos5l_decap_8
X_2629_ _3026_/D _1520_/Y _2628_/B hold373/X _2628_/Y VPWR VGND sg13cmos5l_a22oi_1
XFILLER_43_1018 VPWR VGND sg13cmos5l_decap_8
XFILLER_47_208 VPWR VGND sg13cmos5l_fill_2
XFILLER_29_923 VPWR VGND sg13cmos5l_decap_8
XFILLER_44_904 VPWR VGND sg13cmos5l_decap_8
XFILLER_16_639 VPWR VGND sg13cmos5l_decap_8
XFILLER_24_672 VPWR VGND sg13cmos5l_fill_1
XFILLER_11_311 VPWR VGND sg13cmos5l_decap_8
XFILLER_24_683 VPWR VGND sg13cmos5l_fill_2
XFILLER_8_816 VPWR VGND sg13cmos5l_decap_8
XFILLER_11_388 VPWR VGND sg13cmos5l_decap_4
XFILLER_3_532 VPWR VGND sg13cmos5l_decap_4
XFILLER_11_71 VPWR VGND sg13cmos5l_decap_8
XFILLER_11_82 VPWR VGND sg13cmos5l_fill_1
XFILLER_3_598 VPWR VGND sg13cmos5l_decap_8
XFILLER_47_753 VPWR VGND sg13cmos5l_fill_2
XFILLER_35_915 VPWR VGND sg13cmos5l_decap_8
XFILLER_46_285 VPWR VGND sg13cmos5l_decap_4
X_2980_ _2980_/Q clkload1/A _2980_/D fanout159/X VPWR VGND sg13cmos5l_dfrbpq_1
XFILLER_42_480 VPWR VGND sg13cmos5l_decap_8
X_1931_ _1931_/Y _2300_/B _2301_/B _1930_/Y VPWR VGND sg13cmos5l_o21ai_1
X_1862_ _2598_/A _1862_/A _1862_/B VPWR VGND sg13cmos5l_nand2_1
XFILLER_30_664 VPWR VGND sg13cmos5l_decap_4
XFILLER_30_686 VPWR VGND sg13cmos5l_fill_2
XFILLER_7_860 VPWR VGND sg13cmos5l_decap_8
X_1793_ _2686_/B _2934_/A _1800_/A VPWR VGND sg13cmos5l_nand2_1
X_2414_ _2417_/B _2414_/A _2414_/B _2440_/C VPWR VGND sg13cmos5l_nor3_1
XFILLER_35_0 VPWR VGND sg13cmos5l_decap_8
X_2345_ _2401_/C _3112_/Q _3113_/Q VPWR VGND sg13cmos5l_nand2_1
X_2276_ _2277_/A _1889_/Y _1943_/Y _2259_/X _2275_/Y VPWR VGND sg13cmos5l_a22oi_1
XFILLER_26_937 VPWR VGND sg13cmos5l_decap_8
XFILLER_16_38 VPWR VGND sg13cmos5l_fill_2
XFILLER_16_49 VPWR VGND sg13cmos5l_fill_2
XFILLER_13_609 VPWR VGND sg13cmos5l_fill_1
XFILLER_40_428 VPWR VGND sg13cmos5l_decap_4
XFILLER_12_119 VPWR VGND sg13cmos5l_fill_1
XFILLER_21_664 VPWR VGND sg13cmos5l_decap_8
XFILLER_10_1028 VPWR VGND sg13cmos5l_fill_1
XFILLER_0_524 VPWR VGND sg13cmos5l_decap_8
XFILLER_0_579 VPWR VGND sg13cmos5l_decap_8
XFILLER_29_753 VPWR VGND sg13cmos5l_decap_8
XFILLER_44_723 VPWR VGND sg13cmos5l_decap_8
XFILLER_44_767 VPWR VGND sg13cmos5l_decap_8
XFILLER_44_734 VPWR VGND sg13cmos5l_fill_1
XFILLER_40_940 VPWR VGND sg13cmos5l_decap_8
XFILLER_25_992 VPWR VGND sg13cmos5l_decap_8
XFILLER_8_602 VPWR VGND sg13cmos5l_decap_8
XFILLER_11_130 VPWR VGND sg13cmos5l_fill_1
XFILLER_8_646 VPWR VGND sg13cmos5l_fill_2
XFILLER_12_675 VPWR VGND sg13cmos5l_decap_8
XFILLER_7_145 VPWR VGND sg13cmos5l_fill_1
XFILLER_22_92 VPWR VGND sg13cmos5l_decap_8
XFILLER_4_874 VPWR VGND sg13cmos5l_decap_8
XFILLER_3_340 VPWR VGND sg13cmos5l_decap_8
XFILLER_39_517 VPWR VGND sg13cmos5l_decap_8
XFILLER_39_528 VPWR VGND sg13cmos5l_fill_2
X_2130_ _2130_/Y _1917_/B _2093_/Y _1982_/A VPWR VGND sg13cmos5l_a21oi_1
X_2061_ _2061_/Y _2022_/A _2601_/A VPWR VGND sg13cmos5l_nand2b_1
XFILLER_19_241 VPWR VGND sg13cmos5l_decap_8
XFILLER_47_561 VPWR VGND sg13cmos5l_fill_1
XFILLER_19_296 VPWR VGND sg13cmos5l_decap_8
XFILLER_22_406 VPWR VGND sg13cmos5l_decap_4
XFILLER_23_918 VPWR VGND sg13cmos5l_decap_8
X_2963_ _2963_/Y _2963_/A _2963_/B _2963_/C VPWR VGND sg13cmos5l_nor3_1
X_1914_ _2035_/B _2108_/A _2038_/B VPWR VGND sg13cmos5l_nand2_1
XFILLER_31_962 VPWR VGND sg13cmos5l_decap_8
X_2894_ _2896_/B _3073_/Q _2895_/C _2895_/B VPWR VGND sg13cmos5l_a21oi_1
XFILLER_30_450 VPWR VGND sg13cmos5l_decap_8
XFILLER_33_1028 VPWR VGND sg13cmos5l_fill_1
XFILLER_8_72 VPWR VGND sg13cmos5l_decap_8
X_1845_ _1845_/Y _1845_/A _1845_/B VPWR VGND sg13cmos5l_nand2_1
X_1776_ _1776_/Y _2596_/A _2612_/A VPWR VGND sg13cmos5l_nor2_1
X_2328_ _2346_/A _3109_/Q _3110_/Q _2328_/C VPWR VGND sg13cmos5l_nor3_1
X_2259_ _2259_/X _2259_/A _2259_/B VPWR VGND sg13cmos5l_and2_1
XFILLER_26_734 VPWR VGND sg13cmos5l_decap_4
XFILLER_26_756 VPWR VGND sg13cmos5l_decap_8
XFILLER_25_255 VPWR VGND sg13cmos5l_decap_8
XFILLER_25_266 VPWR VGND sg13cmos5l_fill_2
XFILLER_13_428 VPWR VGND sg13cmos5l_decap_8
XFILLER_22_995 VPWR VGND sg13cmos5l_decap_8
XFILLER_4_115 VPWR VGND sg13cmos5l_fill_1
XFILLER_1_800 VPWR VGND sg13cmos5l_decap_8
XFILLER_49_804 VPWR VGND sg13cmos5l_decap_8
XFILLER_0_343 VPWR VGND sg13cmos5l_decap_8
XFILLER_1_877 VPWR VGND sg13cmos5l_decap_8
XFILLER_29_550 VPWR VGND sg13cmos5l_decap_8
XFILLER_44_531 VPWR VGND sg13cmos5l_decap_8
XFILLER_44_520 VPWR VGND sg13cmos5l_fill_1
XFILLER_16_211 VPWR VGND sg13cmos5l_decap_8
XFILLER_17_745 VPWR VGND sg13cmos5l_fill_1
XFILLER_16_266 VPWR VGND sg13cmos5l_fill_1
XFILLER_17_789 VPWR VGND sg13cmos5l_decap_8
XFILLER_31_214 VPWR VGND sg13cmos5l_decap_4
XFILLER_31_225 VPWR VGND sg13cmos5l_fill_2
XFILLER_9_933 VPWR VGND sg13cmos5l_decap_8
XFILLER_13_995 VPWR VGND sg13cmos5l_decap_8
XFILLER_8_443 VPWR VGND sg13cmos5l_fill_1
X_1630_ _1631_/C _1628_/X _1629_/Y _1581_/A VPWR VGND sg13cmos5l_o21ai_1
XFILLER_4_671 VPWR VGND sg13cmos5l_decap_8
X_1561_ _1561_/X _1638_/A _1562_/B VPWR VGND sg13cmos5l_and2_1
X_1492_ _2473_/A _2442_/B VPWR VGND sg13cmos5l_inv_1
XFILLER_39_347 VPWR VGND sg13cmos5l_decap_4
X_2113_ _2113_/Y _2113_/A _2231_/B VPWR VGND sg13cmos5l_nor2_1
XFILLER_27_509 VPWR VGND sg13cmos5l_fill_2
X_3093_ _3093_/Q _3093_/CLK _3093_/D fanout164/X VPWR VGND sg13cmos5l_dfrbpq_1
X_2044_ _2051_/C _2204_/A _2043_/Y _2131_/C VPWR VGND sg13cmos5l_o21ai_1
XFILLER_35_542 VPWR VGND sg13cmos5l_decap_4
Xfanout29 _2754_/B _2776_/B VPWR VGND sg13cmos5l_buf_1
Xclkbuf_5_1__f_clk clkload0/A clkbuf_4_0_0_clk/X VPWR VGND sg13cmos5l_buf_8
Xfanout18 _1693_/A _1561_/X VPWR VGND sg13cmos5l_buf_1
XFILLER_22_236 VPWR VGND sg13cmos5l_decap_8
X_2946_ _2952_/B _3037_/Q _2946_/B VPWR VGND sg13cmos5l_xor2_1
X_2877_ _2877_/Y _2881_/B _2877_/B VPWR VGND sg13cmos5l_nand2_1
XFILLER_30_280 VPWR VGND sg13cmos5l_decap_8
X_1828_ _1828_/X _2244_/A _1861_/A _1862_/B VPWR VGND sg13cmos5l_or3_1
Xhold410 _2618_/B _2617_/Y VPWR VGND sg13cmos5l_dlygate4sd3_1
Xhold421 _3038_/D _2732_/Y VPWR VGND sg13cmos5l_dlygate4sd3_1
Xhold432 hold432/X _3037_/Q VPWR VGND sg13cmos5l_dlygate4sd3_1
Xhold454 _2407_/B _2406_/Y VPWR VGND sg13cmos5l_dlygate4sd3_1
XFILLER_1_107 VPWR VGND sg13cmos5l_decap_8
X_1759_ _1759_/Y _1762_/B _1759_/B VPWR VGND sg13cmos5l_nand2_1
Xhold443 _1499_/A _3088_/Q VPWR VGND sg13cmos5l_dlygate4sd3_1
Xhold465 _2755_/A _3042_/Q VPWR VGND sg13cmos5l_dlygate4sd3_1
XFILLER_38_14 VPWR VGND sg13cmos5l_decap_8
XFILLER_38_47 VPWR VGND sg13cmos5l_decap_8
XFILLER_46_818 VPWR VGND sg13cmos5l_fill_2
XFILLER_39_870 VPWR VGND sg13cmos5l_decap_8
XFILLER_38_391 VPWR VGND sg13cmos5l_decap_8
XFILLER_14_715 VPWR VGND sg13cmos5l_fill_1
XFILLER_13_225 VPWR VGND sg13cmos5l_decap_8
XFILLER_14_726 VPWR VGND sg13cmos5l_decap_8
XFILLER_14_737 VPWR VGND sg13cmos5l_fill_1
XFILLER_26_575 VPWR VGND sg13cmos5l_decap_4
XFILLER_26_597 VPWR VGND sg13cmos5l_decap_8
XFILLER_41_545 VPWR VGND sg13cmos5l_decap_8
XFILLER_14_759 VPWR VGND sg13cmos5l_decap_8
XFILLER_21_291 VPWR VGND sg13cmos5l_decap_8
XFILLER_6_914 VPWR VGND sg13cmos5l_decap_8
XFILLER_10_965 VPWR VGND sg13cmos5l_decap_8
XFILLER_5_446 VPWR VGND sg13cmos5l_fill_2
XFILLER_5_424 VPWR VGND sg13cmos5l_fill_2
XFILLER_5_479 VPWR VGND sg13cmos5l_fill_1
XFILLER_0_151 VPWR VGND sg13cmos5l_decap_8
XFILLER_1_674 VPWR VGND sg13cmos5l_decap_8
XFILLER_49_667 VPWR VGND sg13cmos5l_decap_8
XFILLER_23_1016 VPWR VGND sg13cmos5l_decap_8
XFILLER_23_1027 VPWR VGND sg13cmos5l_fill_2
XFILLER_48_155 VPWR VGND sg13cmos5l_fill_1
XFILLER_36_306 VPWR VGND sg13cmos5l_fill_1
XFILLER_45_840 VPWR VGND sg13cmos5l_decap_8
XFILLER_17_520 VPWR VGND sg13cmos5l_decap_8
XFILLER_28_91 VPWR VGND sg13cmos5l_decap_8
XFILLER_44_350 VPWR VGND sg13cmos5l_decap_8
XFILLER_45_884 VPWR VGND sg13cmos5l_decap_8
XFILLER_17_586 VPWR VGND sg13cmos5l_decap_8
XFILLER_32_523 VPWR VGND sg13cmos5l_fill_1
XFILLER_20_707 VPWR VGND sg13cmos5l_decap_8
XFILLER_32_567 VPWR VGND sg13cmos5l_decap_8
X_2800_ _2801_/C _2800_/A _2800_/B _2800_/C _2800_/D VPWR VGND sg13cmos5l_nand4_1
XFILLER_13_770 VPWR VGND sg13cmos5l_decap_8
XFILLER_32_578 VPWR VGND sg13cmos5l_fill_2
X_2731_ _2732_/B _2855_/A _2729_/X _2730_/Y VPWR VGND sg13cmos5l_o21ai_1
XFILLER_9_730 VPWR VGND sg13cmos5l_decap_8
XFILLER_13_792 VPWR VGND sg13cmos5l_decap_8
XFILLER_8_273 VPWR VGND sg13cmos5l_decap_8
XFILLER_8_251 VPWR VGND sg13cmos5l_fill_2
XFILLER_8_240 VPWR VGND sg13cmos5l_fill_1
XFILLER_30_1009 VPWR VGND sg13cmos5l_decap_8
X_2662_ _2664_/B _2662_/A _2662_/B VPWR VGND sg13cmos5l_xnor2_1
XFILLER_8_295 VPWR VGND sg13cmos5l_decap_8
X_2593_ _3013_/D _2967_/A _2568_/A _2577_/B VPWR VGND sg13cmos5l_o21ai_1
X_1613_ _1613_/Y _1633_/B _1619_/C _1613_/C VPWR VGND sg13cmos5l_nand3_1
X_1544_ _1547_/A _3131_/Q _1598_/A VPWR VGND sg13cmos5l_nor2b_1
Xclkbuf_4_7_0_clk clkbuf_4_7_0_clk/X clkbuf_0_clk/X VPWR VGND sg13cmos5l_buf_8
XFILLER_39_177 VPWR VGND sg13cmos5l_decap_8
XFILLER_27_306 VPWR VGND sg13cmos5l_decap_8
XFILLER_28_818 VPWR VGND sg13cmos5l_fill_1
X_3076_ _3076_/Q clkload5/A _3076_/D fanout172/X VPWR VGND sg13cmos5l_dfrbpq_1
XFILLER_36_873 VPWR VGND sg13cmos5l_decap_8
X_2027_ _2028_/D _2025_/Y _2026_/Y _1895_/A VPWR VGND sg13cmos5l_a21oi_1
XFILLER_23_512 VPWR VGND sg13cmos5l_decap_8
XFILLER_11_718 VPWR VGND sg13cmos5l_decap_8
X_2929_ _2940_/A _2947_/A _2929_/B VPWR VGND sg13cmos5l_xnor2_1
XFILLER_3_917 VPWR VGND sg13cmos5l_decap_8
XFILLER_2_405 VPWR VGND sg13cmos5l_decap_8
Xhold240 _3019_/D _2607_/Y VPWR VGND sg13cmos5l_dlygate4sd3_1
Xhold251 _2969_/D _2451_/Y VPWR VGND sg13cmos5l_dlygate4sd3_1
Xhold262 _2975_/D _2478_/Y VPWR VGND sg13cmos5l_dlygate4sd3_1
XFILLER_46_1027 VPWR VGND sg13cmos5l_fill_2
XFILLER_46_1016 VPWR VGND sg13cmos5l_decap_8
Xhold295 _3048_/D _2811_/Y VPWR VGND sg13cmos5l_dlygate4sd3_1
Xhold273 _3110_/D _2413_/X VPWR VGND sg13cmos5l_dlygate4sd3_1
Xhold284 _2397_/A _3123_/Q VPWR VGND sg13cmos5l_dlygate4sd3_1
XFILLER_49_57 VPWR VGND sg13cmos5l_decap_8
XFILLER_46_604 VPWR VGND sg13cmos5l_fill_2
XFILLER_46_637 VPWR VGND sg13cmos5l_decap_8
XFILLER_42_832 VPWR VGND sg13cmos5l_decap_8
XFILLER_14_501 VPWR VGND sg13cmos5l_decap_8
XFILLER_14_512 VPWR VGND sg13cmos5l_fill_2
XFILLER_26_350 VPWR VGND sg13cmos5l_fill_2
XFILLER_26_383 VPWR VGND sg13cmos5l_decap_8
XFILLER_14_534 VPWR VGND sg13cmos5l_decap_4
XFILLER_6_711 VPWR VGND sg13cmos5l_decap_8
XFILLER_6_788 VPWR VGND sg13cmos5l_decap_8
XFILLER_5_232 VPWR VGND sg13cmos5l_fill_2
XFILLER_5_265 VPWR VGND sg13cmos5l_decap_8
XFILLER_2_950 VPWR VGND sg13cmos5l_decap_8
XFILLER_1_460 VPWR VGND sg13cmos5l_fill_2
XFILLER_49_420 VPWR VGND sg13cmos5l_decap_8
XFILLER_7_1021 VPWR VGND sg13cmos5l_decap_8
XFILLER_37_615 VPWR VGND sg13cmos5l_fill_2
XFILLER_37_604 VPWR VGND sg13cmos5l_decap_8
XFILLER_36_103 VPWR VGND sg13cmos5l_decap_8
XFILLER_36_136 VPWR VGND sg13cmos5l_decap_4
XFILLER_18_873 VPWR VGND sg13cmos5l_decap_8
XFILLER_44_191 VPWR VGND sg13cmos5l_decap_4
XFILLER_33_865 VPWR VGND sg13cmos5l_decap_8
XFILLER_20_548 VPWR VGND sg13cmos5l_decap_8
X_2714_ _3036_/D _2714_/A VPWR VGND sg13cmos5l_inv_1
XFILLER_10_18 VPWR VGND sg13cmos5l_decap_8
X_2645_ _2645_/Y _2855_/A _2754_/B VPWR VGND sg13cmos5l_nor2_1
XFILLER_10_29 VPWR VGND sg13cmos5l_fill_1
X_2576_ _2997_/D hold385/X _2499_/B _2577_/B VPWR VGND sg13cmos5l_mux2_1
X_1527_ _1530_/B _1527_/A _2979_/Q _2353_/S VPWR VGND sg13cmos5l_nor3_1
XFILLER_28_615 VPWR VGND sg13cmos5l_decap_8
X_3128_ _3128_/Q _3129_/CLK _3128_/D fanout174/X VPWR VGND sg13cmos5l_dfrbpq_1
X_3059_ _3059_/Q _3060_/CLK _3059_/D fanout175/X VPWR VGND sg13cmos5l_dfrbpq_1
XFILLER_35_37 VPWR VGND sg13cmos5l_decap_8
XFILLER_27_169 VPWR VGND sg13cmos5l_fill_2
XFILLER_23_342 VPWR VGND sg13cmos5l_decap_4
XFILLER_23_353 VPWR VGND sg13cmos5l_decap_8
XFILLER_23_386 VPWR VGND sg13cmos5l_decap_8
XFILLER_3_714 VPWR VGND sg13cmos5l_decap_8
XFILLER_2_268 VPWR VGND sg13cmos5l_decap_8
XFILLER_47_902 VPWR VGND sg13cmos5l_decap_8
XFILLER_19_604 VPWR VGND sg13cmos5l_fill_1
XFILLER_20_1008 VPWR VGND sg13cmos5l_decap_8
XFILLER_47_979 VPWR VGND sg13cmos5l_decap_8
XFILLER_15_832 VPWR VGND sg13cmos5l_decap_8
XFILLER_30_813 VPWR VGND sg13cmos5l_decap_8
XFILLER_41_194 VPWR VGND sg13cmos5l_decap_8
XFILLER_41_80 VPWR VGND sg13cmos5l_fill_2
XFILLER_6_541 VPWR VGND sg13cmos5l_decap_8
XFILLER_6_574 VPWR VGND sg13cmos5l_decap_8
X_2430_ _2430_/Y _3090_/Q _2429_/B _2429_/C VPWR VGND sg13cmos5l_a21oi_1
XFILLER_29_1000 VPWR VGND sg13cmos5l_decap_8
XFILLER_37_4 VPWR VGND sg13cmos5l_fill_1
X_2361_ _3130_/D _2367_/A _2365_/A VPWR VGND sg13cmos5l_nand2_1
X_2292_ _2292_/Y _2289_/X _2291_/Y _2032_/A VPWR VGND sg13cmos5l_a21oi_1
XFILLER_49_261 VPWR VGND sg13cmos5l_decap_8
XFILLER_38_946 VPWR VGND sg13cmos5l_decap_8
XFILLER_2_63 VPWR VGND sg13cmos5l_fill_2
XFILLER_37_445 VPWR VGND sg13cmos5l_fill_2
XFILLER_21_813 VPWR VGND sg13cmos5l_fill_2
XFILLER_32_183 VPWR VGND sg13cmos5l_decap_8
XFILLER_20_367 VPWR VGND sg13cmos5l_decap_4
X_2628_ _2628_/Y _2628_/A _2628_/B VPWR VGND sg13cmos5l_nor2_1
X_2559_ _2560_/B _3005_/Q _3004_/Q VPWR VGND sg13cmos5l_xor2_1
XFILLER_29_902 VPWR VGND sg13cmos5l_decap_8
XFILLER_29_979 VPWR VGND sg13cmos5l_decap_8
XFILLER_46_69 VPWR VGND sg13cmos5l_decap_8
XFILLER_28_478 VPWR VGND sg13cmos5l_decap_8
XFILLER_28_489 VPWR VGND sg13cmos5l_decap_8
XFILLER_11_301 VPWR VGND sg13cmos5l_fill_1
XFILLER_12_846 VPWR VGND sg13cmos5l_decap_8
XFILLER_11_345 VPWR VGND sg13cmos5l_decap_8
XFILLER_12_868 VPWR VGND sg13cmos5l_decap_4
XFILLER_11_367 VPWR VGND sg13cmos5l_fill_2
XFILLER_11_50 VPWR VGND sg13cmos5l_decap_8
XFILLER_3_566 VPWR VGND sg13cmos5l_decap_8
XFILLER_46_231 VPWR VGND sg13cmos5l_fill_1
XFILLER_46_264 VPWR VGND sg13cmos5l_decap_8
XFILLER_19_467 VPWR VGND sg13cmos5l_decap_8
XFILLER_15_640 VPWR VGND sg13cmos5l_fill_2
X_1930_ _1930_/Y _2300_/B _2108_/A _2311_/A _2194_/A VPWR VGND sg13cmos5l_nand4_1
X_1861_ _1861_/Y _1861_/A _2594_/A VPWR VGND sg13cmos5l_nor2_1
X_1792_ _2947_/B _2442_/A _2442_/B VPWR VGND sg13cmos5l_and2_1
XFILLER_42_2 VPWR VGND sg13cmos5l_fill_1
X_2413_ _2413_/X _2413_/A _2413_/B VPWR VGND sg13cmos5l_xor2_1
X_2344_ _2370_/B _2412_/A _2335_/C VPWR VGND sg13cmos5l_nor2b_1
XFILLER_28_0 VPWR VGND sg13cmos5l_fill_1
XFILLER_38_721 VPWR VGND sg13cmos5l_decap_8
X_2275_ _2275_/Y _2599_/A _2011_/D _2118_/A VPWR VGND sg13cmos5l_a21oi_1
XFILLER_37_275 VPWR VGND sg13cmos5l_decap_4
XFILLER_26_916 VPWR VGND sg13cmos5l_decap_8
XFILLER_21_643 VPWR VGND sg13cmos5l_decap_8
XFILLER_20_142 VPWR VGND sg13cmos5l_decap_8
XFILLER_20_175 VPWR VGND sg13cmos5l_decap_8
XFILLER_10_1007 VPWR VGND sg13cmos5l_decap_8
XFILLER_0_503 VPWR VGND sg13cmos5l_decap_8
XFILLER_43_201 VPWR VGND sg13cmos5l_fill_2
XFILLER_29_787 VPWR VGND sg13cmos5l_decap_8
XFILLER_29_798 VPWR VGND sg13cmos5l_fill_1
XFILLER_43_223 VPWR VGND sg13cmos5l_decap_8
XFILLER_16_448 VPWR VGND sg13cmos5l_decap_4
XFILLER_17_949 VPWR VGND sg13cmos5l_decap_8
XFILLER_25_971 VPWR VGND sg13cmos5l_decap_8
XFILLER_43_278 VPWR VGND sg13cmos5l_decap_8
XFILLER_19_1021 VPWR VGND sg13cmos5l_decap_8
XFILLER_12_632 VPWR VGND sg13cmos5l_decap_8
XFILLER_40_996 VPWR VGND sg13cmos5l_decap_8
XFILLER_12_687 VPWR VGND sg13cmos5l_decap_4
XFILLER_8_669 VPWR VGND sg13cmos5l_decap_8
XFILLER_7_179 VPWR VGND sg13cmos5l_fill_1
XFILLER_4_853 VPWR VGND sg13cmos5l_decap_8
XFILLER_3_363 VPWR VGND sg13cmos5l_fill_2
XFILLER_26_1014 VPWR VGND sg13cmos5l_decap_8
X_2060_ _2060_/Y _2059_/Y _2194_/B VPWR VGND sg13cmos5l_nand2b_1
XFILLER_19_220 VPWR VGND sg13cmos5l_decap_8
XFILLER_47_573 VPWR VGND sg13cmos5l_decap_4
XFILLER_35_779 VPWR VGND sg13cmos5l_decap_8
X_2962_ _2962_/Y _2473_/A _2529_/A _2508_/Y _2529_/Y VPWR VGND sg13cmos5l_a22oi_1
XFILLER_15_481 VPWR VGND sg13cmos5l_decap_4
XFILLER_16_993 VPWR VGND sg13cmos5l_decap_8
X_1913_ _2038_/B _1966_/B _1913_/B VPWR VGND sg13cmos5l_nand2_1
XFILLER_31_941 VPWR VGND sg13cmos5l_decap_8
X_2893_ _3073_/D _2896_/A _2892_/Y _2891_/Y VPWR VGND sg13cmos5l_o21ai_1
X_1844_ _2118_/A _1844_/A _1844_/B VPWR VGND sg13cmos5l_nor2_1
X_1775_ _1778_/B _2246_/A _2597_/C _1775_/C VPWR VGND sg13cmos5l_nand3_1
XFILLER_7_680 VPWR VGND sg13cmos5l_decap_4
X_2327_ _2338_/B _3109_/Q _2327_/B _2327_/C VPWR VGND sg13cmos5l_and3_1
X_2258_ _2258_/Y _1838_/Y _2257_/Y _2268_/A VPWR VGND sg13cmos5l_o21ai_1
X_2189_ _2199_/C _2184_/Y _2188_/Y _2282_/A VPWR VGND sg13cmos5l_a21o_1
XFILLER_41_716 VPWR VGND sg13cmos5l_decap_8
XFILLER_41_705 VPWR VGND sg13cmos5l_fill_2
XFILLER_14_919 VPWR VGND sg13cmos5l_decap_8
XFILLER_25_234 VPWR VGND sg13cmos5l_decap_8
XFILLER_26_768 VPWR VGND sg13cmos5l_fill_2
XFILLER_40_237 VPWR VGND sg13cmos5l_fill_1
XFILLER_21_451 VPWR VGND sg13cmos5l_decap_8
XFILLER_22_974 VPWR VGND sg13cmos5l_decap_8
XFILLER_49_1014 VPWR VGND sg13cmos5l_decap_8
XFILLER_0_322 VPWR VGND sg13cmos5l_decap_8
XFILLER_1_856 VPWR VGND sg13cmos5l_decap_8
XFILLER_48_315 VPWR VGND sg13cmos5l_decap_8
XFILLER_16_201 VPWR VGND sg13cmos5l_decap_4
XFILLER_17_779 VPWR VGND sg13cmos5l_decap_4
XFILLER_9_912 VPWR VGND sg13cmos5l_decap_8
XFILLER_13_974 VPWR VGND sg13cmos5l_decap_8
XFILLER_12_484 VPWR VGND sg13cmos5l_decap_8
XFILLER_8_488 VPWR VGND sg13cmos5l_decap_8
XFILLER_9_989 VPWR VGND sg13cmos5l_decap_8
X_1560_ _1562_/B _1560_/A _1560_/B VPWR VGND sg13cmos5l_xor2_1
XFILLER_4_650 VPWR VGND sg13cmos5l_decap_8
X_1491_ _1705_/C _1718_/B VPWR VGND sg13cmos5l_inv_1
XFILLER_39_326 VPWR VGND sg13cmos5l_decap_8
X_2112_ _2222_/A _2112_/A _2175_/B VPWR VGND sg13cmos5l_nand2_1
X_3092_ _3092_/Q _3093_/CLK _3092_/D fanout164/X VPWR VGND sg13cmos5l_dfrbpq_1
XFILLER_48_893 VPWR VGND sg13cmos5l_decap_8
XFILLER_47_392 VPWR VGND sg13cmos5l_decap_8
X_2043_ _2043_/Y _2047_/C _1952_/D _2601_/A _2081_/A _2240_/A VPWR VGND sg13cmos5l_a221oi_1
Xfanout19 _1720_/A _1561_/X VPWR VGND sg13cmos5l_buf_1
XFILLER_22_215 VPWR VGND sg13cmos5l_decap_8
XFILLER_22_259 VPWR VGND sg13cmos5l_fill_1
XFILLER_13_18 VPWR VGND sg13cmos5l_decap_8
X_2945_ _2946_/B _2919_/A _1796_/B _1783_/Y VPWR VGND sg13cmos5l_a21oi_1
X_2876_ _2877_/B _3068_/Q _2880_/D _2875_/B VPWR VGND sg13cmos5l_a21o_1
XFILLER_30_270 VPWR VGND sg13cmos5l_fill_2
X_1827_ _2246_/B _1862_/A _2594_/A VPWR VGND sg13cmos5l_nand2_1
Xhold400 hold400/X _3009_/Q VPWR VGND sg13cmos5l_dlygate4sd3_1
Xhold411 _2412_/A _3109_/Q VPWR VGND sg13cmos5l_dlygate4sd3_1
Xhold433 _1510_/A _3039_/Q VPWR VGND sg13cmos5l_dlygate4sd3_1
Xhold422 _2417_/A _3112_/Q VPWR VGND sg13cmos5l_dlygate4sd3_1
X_1758_ _1759_/B _1755_/A _1755_/B _1482_/Y VPWR VGND sg13cmos5l_o21ai_1
Xhold444 _3088_/D _2968_/Y VPWR VGND sg13cmos5l_dlygate4sd3_1
Xhold455 _2605_/C _3016_/Q VPWR VGND sg13cmos5l_dlygate4sd3_1
X_1689_ _1689_/Y _1669_/Y _1688_/Y _1686_/Y VPWR VGND sg13cmos5l_o21ai_1
XFILLER_38_37 VPWR VGND sg13cmos5l_decap_4
XFILLER_38_370 VPWR VGND sg13cmos5l_fill_1
XFILLER_26_554 VPWR VGND sg13cmos5l_decap_8
XFILLER_41_524 VPWR VGND sg13cmos5l_decap_8
XFILLER_13_204 VPWR VGND sg13cmos5l_decap_8
XFILLER_41_579 VPWR VGND sg13cmos5l_decap_4
XFILLER_13_259 VPWR VGND sg13cmos5l_fill_2
XFILLER_10_944 VPWR VGND sg13cmos5l_decap_8
XFILLER_21_270 VPWR VGND sg13cmos5l_decap_8
XFILLER_22_793 VPWR VGND sg13cmos5l_decap_8
XFILLER_5_458 VPWR VGND sg13cmos5l_decap_8
XFILLER_0_130 VPWR VGND sg13cmos5l_decap_8
XFILLER_1_653 VPWR VGND sg13cmos5l_decap_8
XFILLER_49_646 VPWR VGND sg13cmos5l_decap_8
XFILLER_28_70 VPWR VGND sg13cmos5l_decap_8
XFILLER_45_863 VPWR VGND sg13cmos5l_decap_8
XFILLER_17_565 VPWR VGND sg13cmos5l_decap_8
X_2730_ _2730_/Y _2730_/A1 _1525_/Y _2730_/B1 VPWR VGND sg13cmos5l_a21oi_1
X_2661_ _2662_/B _2934_/A _2686_/C _1796_/B VPWR VGND sg13cmos5l_o21ai_1
XFILLER_9_786 VPWR VGND sg13cmos5l_decap_8
X_1612_ _1631_/B _1698_/A _1612_/B VPWR VGND sg13cmos5l_or2_1
X_2592_ _3012_/D hold366/X input2/X _2592_/S VPWR VGND sg13cmos5l_mux2_1
X_1543_ _1567_/A _3132_/Q _2246_/A VPWR VGND sg13cmos5l_xnor2_1
XFILLER_5_74 VPWR VGND sg13cmos5l_decap_8
XFILLER_4_491 VPWR VGND sg13cmos5l_decap_8
XFILLER_39_156 VPWR VGND sg13cmos5l_decap_8
X_3075_ _3075_/Q clkload5/A _3075_/D fanout172/X VPWR VGND sg13cmos5l_dfrbpq_1
XFILLER_36_852 VPWR VGND sg13cmos5l_decap_8
X_2026_ _2026_/Y _2308_/A _2266_/B VPWR VGND sg13cmos5l_nand2_1
XFILLER_39_1024 VPWR VGND sg13cmos5l_decap_4
XFILLER_35_384 VPWR VGND sg13cmos5l_decap_8
X_2928_ _2928_/Y _3038_/Q _2928_/B VPWR VGND sg13cmos5l_xnor2_1
X_2859_ _2859_/Y _2860_/B _2879_/B VPWR VGND sg13cmos5l_nand2_1
Xhold230 _2988_/D _2534_/Y VPWR VGND sg13cmos5l_dlygate4sd3_1
XFILLER_2_439 VPWR VGND sg13cmos5l_decap_8
Xhold252 _2628_/A _3026_/Q VPWR VGND sg13cmos5l_dlygate4sd3_1
Xhold241 _2914_/B _3078_/Q VPWR VGND sg13cmos5l_dlygate4sd3_1
XFILLER_49_36 VPWR VGND sg13cmos5l_decap_8
Xhold296 _2490_/A _2980_/Q VPWR VGND sg13cmos5l_dlygate4sd3_1
XFILLER_6_8 VPWR VGND sg13cmos5l_fill_1
Xhold285 _2398_/B _2397_/Y VPWR VGND sg13cmos5l_dlygate4sd3_1
Xhold263 _2907_/A _3077_/Q VPWR VGND sg13cmos5l_dlygate4sd3_1
Xhold274 _2480_/A _2976_/Q VPWR VGND sg13cmos5l_dlygate4sd3_1
XFILLER_45_104 VPWR VGND sg13cmos5l_decap_8
XFILLER_18_329 VPWR VGND sg13cmos5l_decap_8
XFILLER_27_885 VPWR VGND sg13cmos5l_decap_8
XFILLER_41_332 VPWR VGND sg13cmos5l_decap_4
XFILLER_14_557 VPWR VGND sg13cmos5l_decap_8
XFILLER_42_899 VPWR VGND sg13cmos5l_fill_2
XFILLER_42_888 VPWR VGND sg13cmos5l_decap_8
XFILLER_41_365 VPWR VGND sg13cmos5l_fill_2
XFILLER_14_61 VPWR VGND sg13cmos5l_decap_8
XFILLER_10_774 VPWR VGND sg13cmos5l_decap_8
XFILLER_6_767 VPWR VGND sg13cmos5l_decap_8
XFILLER_5_244 VPWR VGND sg13cmos5l_decap_8
XFILLER_7_1000 VPWR VGND sg13cmos5l_decap_8
XFILLER_49_476 VPWR VGND sg13cmos5l_decap_8
XFILLER_36_159 VPWR VGND sg13cmos5l_fill_2
XFILLER_18_852 VPWR VGND sg13cmos5l_decap_8
XFILLER_45_660 VPWR VGND sg13cmos5l_decap_8
XFILLER_17_373 VPWR VGND sg13cmos5l_decap_4
XFILLER_33_844 VPWR VGND sg13cmos5l_decap_8
XFILLER_32_343 VPWR VGND sg13cmos5l_fill_2
XFILLER_32_376 VPWR VGND sg13cmos5l_decap_8
XFILLER_32_398 VPWR VGND sg13cmos5l_fill_1
X_2713_ _2714_/A hold437/X _2747_/A _2711_/Y _2712_/Y VPWR VGND sg13cmos5l_a22oi_1
X_2644_ _2776_/B _2968_/A _2746_/A _2854_/A VPWR VGND sg13cmos5l_a21o_1
X_2575_ _2575_/Y _2512_/B _2577_/B _2574_/Y VPWR VGND sg13cmos5l_a21oi_1
X_1526_ _2395_/A _2392_/A _2353_/S VPWR VGND sg13cmos5l_and2_1
X_3127_ _3127_/Q clkload5/A _3127_/D fanout177/X VPWR VGND sg13cmos5l_dfrbpq_1
XFILLER_28_638 VPWR VGND sg13cmos5l_fill_1
XFILLER_27_148 VPWR VGND sg13cmos5l_decap_8
XFILLER_43_619 VPWR VGND sg13cmos5l_fill_2
X_3058_ _3058_/Q clkload7/A _3058_/D fanout175/X VPWR VGND sg13cmos5l_dfrbpq_1
XFILLER_36_682 VPWR VGND sg13cmos5l_fill_1
XFILLER_36_660 VPWR VGND sg13cmos5l_decap_8
XFILLER_24_811 VPWR VGND sg13cmos5l_decap_8
X_2009_ _2009_/Y _2240_/B _2251_/B _1997_/Y VPWR VGND sg13cmos5l_o21ai_1
XFILLER_23_310 VPWR VGND sg13cmos5l_fill_2
XFILLER_24_888 VPWR VGND sg13cmos5l_decap_8
XFILLER_11_538 VPWR VGND sg13cmos5l_decap_4
XFILLER_7_509 VPWR VGND sg13cmos5l_fill_2
XFILLER_13_1016 VPWR VGND sg13cmos5l_decap_8
XFILLER_13_1027 VPWR VGND sg13cmos5l_fill_2
XFILLER_2_247 VPWR VGND sg13cmos5l_decap_8
XFILLER_47_958 VPWR VGND sg13cmos5l_decap_8
XFILLER_15_811 VPWR VGND sg13cmos5l_decap_8
XFILLER_33_129 VPWR VGND sg13cmos5l_decap_8
XFILLER_42_663 VPWR VGND sg13cmos5l_decap_8
XFILLER_42_641 VPWR VGND sg13cmos5l_decap_8
XFILLER_14_365 VPWR VGND sg13cmos5l_decap_8
XFILLER_14_376 VPWR VGND sg13cmos5l_fill_2
XFILLER_14_387 VPWR VGND sg13cmos5l_fill_2
XFILLER_25_82 VPWR VGND sg13cmos5l_decap_8
Xclkbuf_4_6_0_clk clkbuf_4_6_0_clk/X clkbuf_0_clk/X VPWR VGND sg13cmos5l_buf_8
XFILLER_30_869 VPWR VGND sg13cmos5l_decap_8
XFILLER_6_520 VPWR VGND sg13cmos5l_decap_8
X_2360_ _2365_/A _2369_/A _2368_/A VPWR VGND sg13cmos5l_nor2_1
X_2291_ _2291_/Y _2404_/C _2290_/X _2287_/Y VPWR VGND sg13cmos5l_a21oi_1
XFILLER_49_251 VPWR VGND sg13cmos5l_fill_1
XFILLER_2_31 VPWR VGND sg13cmos5l_decap_8
XFILLER_38_925 VPWR VGND sg13cmos5l_decap_8
XFILLER_37_479 VPWR VGND sg13cmos5l_decap_8
XFILLER_18_671 VPWR VGND sg13cmos5l_decap_8
XFILLER_24_118 VPWR VGND sg13cmos5l_decap_8
XFILLER_36_1027 VPWR VGND sg13cmos5l_fill_2
XFILLER_33_641 VPWR VGND sg13cmos5l_decap_8
XFILLER_33_685 VPWR VGND sg13cmos5l_decap_8
XFILLER_21_869 VPWR VGND sg13cmos5l_decap_8
X_2627_ _2627_/Y _2627_/A _2630_/B VPWR VGND sg13cmos5l_nand2_1
X_2558_ _2558_/Y _3007_/Q _3006_/Q _2558_/C _2558_/D VPWR VGND sg13cmos5l_nor4_1
X_1509_ _2948_/A _1509_/A VPWR VGND sg13cmos5l_inv_1
X_2489_ _2489_/Y _2673_/A _2490_/B hold302/X VPWR VGND sg13cmos5l_a21oi_1
XFILLER_28_424 VPWR VGND sg13cmos5l_decap_8
XFILLER_29_958 VPWR VGND sg13cmos5l_decap_8
XFILLER_44_939 VPWR VGND sg13cmos5l_decap_8
XFILLER_16_608 VPWR VGND sg13cmos5l_decap_8
XFILLER_16_619 VPWR VGND sg13cmos5l_fill_2
XFILLER_43_438 VPWR VGND sg13cmos5l_decap_4
XFILLER_36_490 VPWR VGND sg13cmos5l_fill_1
XFILLER_23_140 VPWR VGND sg13cmos5l_decap_8
XFILLER_12_825 VPWR VGND sg13cmos5l_decap_8
XFILLER_23_151 VPWR VGND sg13cmos5l_decap_8
XFILLER_23_162 VPWR VGND sg13cmos5l_fill_2
XFILLER_23_173 VPWR VGND sg13cmos5l_fill_2
XFILLER_24_685 VPWR VGND sg13cmos5l_fill_1
XFILLER_23_195 VPWR VGND sg13cmos5l_fill_2
XFILLER_20_880 VPWR VGND sg13cmos5l_fill_2
XFILLER_3_512 VPWR VGND sg13cmos5l_fill_2
XFILLER_11_95 VPWR VGND sg13cmos5l_decap_8
XFILLER_4_1014 VPWR VGND sg13cmos5l_decap_8
XFILLER_47_755 VPWR VGND sg13cmos5l_fill_1
XFILLER_46_210 VPWR VGND sg13cmos5l_decap_8
XFILLER_19_435 VPWR VGND sg13cmos5l_fill_2
XFILLER_46_243 VPWR VGND sg13cmos5l_decap_8
XFILLER_14_140 VPWR VGND sg13cmos5l_fill_1
XFILLER_43_983 VPWR VGND sg13cmos5l_decap_8
XFILLER_14_173 VPWR VGND sg13cmos5l_decap_8
XFILLER_15_674 VPWR VGND sg13cmos5l_decap_4
X_1860_ _2294_/B _2147_/A _2135_/A _2186_/B VPWR VGND sg13cmos5l_o21ai_1
XFILLER_30_699 VPWR VGND sg13cmos5l_decap_8
X_1791_ _2674_/A _2934_/A _1800_/A _2442_/C VPWR VGND sg13cmos5l_o21ai_1
XFILLER_11_880 VPWR VGND sg13cmos5l_decap_8
XFILLER_7_895 VPWR VGND sg13cmos5l_decap_8
X_2412_ _2440_/C _2412_/A _2413_/A _2412_/C VPWR VGND sg13cmos5l_nand3_1
X_2343_ _2348_/C _2341_/Y _2342_/Y _1778_/B VPWR VGND sg13cmos5l_o21ai_1
XFILLER_38_700 VPWR VGND sg13cmos5l_decap_8
X_2274_ _2274_/Y _2269_/Y _2273_/Y _2263_/Y VPWR VGND sg13cmos5l_o21ai_1
XFILLER_16_18 VPWR VGND sg13cmos5l_decap_4
XFILLER_21_622 VPWR VGND sg13cmos5l_decap_8
XFILLER_33_460 VPWR VGND sg13cmos5l_decap_8
XFILLER_33_471 VPWR VGND sg13cmos5l_fill_1
XFILLER_34_994 VPWR VGND sg13cmos5l_decap_8
XFILLER_20_121 VPWR VGND sg13cmos5l_decap_8
XFILLER_20_154 VPWR VGND sg13cmos5l_fill_2
X_1989_ _1989_/Y _2183_/A _1989_/B VPWR VGND sg13cmos5l_nor2_1
XFILLER_4_309 VPWR VGND sg13cmos5l_decap_8
XFILLER_48_508 VPWR VGND sg13cmos5l_decap_4
XFILLER_0_559 VPWR VGND sg13cmos5l_decap_8
XFILLER_17_928 VPWR VGND sg13cmos5l_decap_8
XFILLER_16_416 VPWR VGND sg13cmos5l_decap_8
XFILLER_43_257 VPWR VGND sg13cmos5l_decap_8
XFILLER_19_1000 VPWR VGND sg13cmos5l_decap_8
XFILLER_25_950 VPWR VGND sg13cmos5l_decap_8
XFILLER_12_611 VPWR VGND sg13cmos5l_decap_8
XFILLER_40_975 VPWR VGND sg13cmos5l_decap_8
XFILLER_11_143 VPWR VGND sg13cmos5l_decap_8
XFILLER_8_648 VPWR VGND sg13cmos5l_fill_1
XFILLER_7_136 VPWR VGND sg13cmos5l_decap_8
XFILLER_11_176 VPWR VGND sg13cmos5l_decap_8
XFILLER_12_699 VPWR VGND sg13cmos5l_decap_4
XFILLER_22_50 VPWR VGND sg13cmos5l_fill_2
XFILLER_7_158 VPWR VGND sg13cmos5l_decap_8
XFILLER_4_832 VPWR VGND sg13cmos5l_decap_8
XFILLER_3_397 VPWR VGND sg13cmos5l_decap_8
XFILLER_47_552 VPWR VGND sg13cmos5l_decap_8
XFILLER_35_747 VPWR VGND sg13cmos5l_decap_4
X_2961_ _2961_/Y _2673_/A _2529_/A _2513_/Y _2960_/Y VPWR VGND sg13cmos5l_a22oi_1
XFILLER_15_460 VPWR VGND sg13cmos5l_decap_8
XFILLER_16_972 VPWR VGND sg13cmos5l_decap_8
XFILLER_31_920 VPWR VGND sg13cmos5l_decap_8
X_1912_ _1912_/Y _2205_/A _2054_/A _2113_/A VPWR VGND sg13cmos5l_o21ai_1
XFILLER_30_430 VPWR VGND sg13cmos5l_decap_8
XFILLER_8_41 VPWR VGND sg13cmos5l_decap_8
X_2892_ _2892_/Y _2892_/A _2895_/C VPWR VGND sg13cmos5l_xnor2_1
XFILLER_31_997 VPWR VGND sg13cmos5l_decap_8
XFILLER_33_1019 VPWR VGND sg13cmos5l_decap_8
X_1843_ _1843_/X _1972_/C _1843_/B _1843_/C VPWR VGND sg13cmos5l_or3_1
X_1774_ _1775_/C _2596_/C _1831_/C VPWR VGND sg13cmos5l_nor2b_1
XFILLER_40_0 VPWR VGND sg13cmos5l_decap_8
X_2326_ _2327_/C _2326_/A _2326_/B _2326_/C VPWR VGND sg13cmos5l_nand3_1
X_2257_ _2257_/Y _1974_/C _2257_/B VPWR VGND sg13cmos5l_nand2b_1
XFILLER_26_714 VPWR VGND sg13cmos5l_decap_4
X_2188_ _2188_/Y _2231_/A _2179_/Y _2187_/Y _2054_/B VPWR VGND sg13cmos5l_a22oi_1
XFILLER_25_213 VPWR VGND sg13cmos5l_decap_8
XFILLER_41_739 VPWR VGND sg13cmos5l_fill_2
XFILLER_40_216 VPWR VGND sg13cmos5l_decap_8
XFILLER_25_279 VPWR VGND sg13cmos5l_fill_1
XFILLER_21_430 VPWR VGND sg13cmos5l_decap_8
XFILLER_22_953 VPWR VGND sg13cmos5l_decap_8
XFILLER_33_290 VPWR VGND sg13cmos5l_decap_8
XFILLER_21_485 VPWR VGND sg13cmos5l_decap_8
XFILLER_21_496 VPWR VGND sg13cmos5l_fill_1
XFILLER_5_607 VPWR VGND sg13cmos5l_decap_4
XFILLER_4_139 VPWR VGND sg13cmos5l_decap_8
XFILLER_1_835 VPWR VGND sg13cmos5l_decap_8
XFILLER_49_839 VPWR VGND sg13cmos5l_decap_8
XFILLER_0_378 VPWR VGND sg13cmos5l_fill_2
Xclkbuf_5_26__f_clk _3036_/CLK clkbuf_4_13_0_clk/X VPWR VGND sg13cmos5l_buf_8
XFILLER_48_349 VPWR VGND sg13cmos5l_decap_8
XFILLER_1_1017 VPWR VGND sg13cmos5l_decap_8
XFILLER_1_1028 VPWR VGND sg13cmos5l_fill_1
XFILLER_17_736 VPWR VGND sg13cmos5l_decap_8
XFILLER_29_585 VPWR VGND sg13cmos5l_decap_8
XFILLER_44_566 VPWR VGND sg13cmos5l_decap_4
XFILLER_16_246 VPWR VGND sg13cmos5l_decap_8
XFILLER_16_257 VPWR VGND sg13cmos5l_fill_2
XFILLER_17_758 VPWR VGND sg13cmos5l_decap_8
XFILLER_44_599 VPWR VGND sg13cmos5l_fill_2
XFILLER_16_279 VPWR VGND sg13cmos5l_decap_8
XFILLER_32_728 VPWR VGND sg13cmos5l_fill_1
XFILLER_32_739 VPWR VGND sg13cmos5l_decap_8
XFILLER_13_953 VPWR VGND sg13cmos5l_decap_8
XFILLER_24_290 VPWR VGND sg13cmos5l_decap_8
XFILLER_25_791 VPWR VGND sg13cmos5l_decap_8
XFILLER_31_227 VPWR VGND sg13cmos5l_fill_1
XFILLER_8_412 VPWR VGND sg13cmos5l_fill_1
XFILLER_12_463 VPWR VGND sg13cmos5l_decap_8
XFILLER_40_783 VPWR VGND sg13cmos5l_decap_8
XFILLER_9_968 VPWR VGND sg13cmos5l_decap_8
XFILLER_33_71 VPWR VGND sg13cmos5l_decap_8
XFILLER_8_467 VPWR VGND sg13cmos5l_fill_2
XFILLER_8_456 VPWR VGND sg13cmos5l_decap_8
X_1490_ _1705_/B _1816_/A VPWR VGND sg13cmos5l_inv_1
XFILLER_39_305 VPWR VGND sg13cmos5l_decap_8
X_3160_ _3160_/X _3160_/A VPWR VGND sg13cmos5l_buf_1
XFILLER_12_4 VPWR VGND sg13cmos5l_fill_2
X_2111_ _2213_/B _2112_/A _2175_/B VPWR VGND sg13cmos5l_and2_1
X_3091_ _3091_/Q _3091_/CLK _3091_/D fanout160/X VPWR VGND sg13cmos5l_dfrbpq_1
XFILLER_48_872 VPWR VGND sg13cmos5l_decap_8
X_2042_ _2081_/A _2047_/C _2202_/B VPWR VGND sg13cmos5l_nor2_1
XFILLER_35_566 VPWR VGND sg13cmos5l_fill_1
XFILLER_35_599 VPWR VGND sg13cmos5l_decap_8
XFILLER_16_791 VPWR VGND sg13cmos5l_decap_8
X_2944_ _2953_/A _3040_/Q _2944_/B VPWR VGND sg13cmos5l_xnor2_1
XFILLER_31_761 VPWR VGND sg13cmos5l_fill_1
X_2875_ _2881_/B _3068_/Q _2875_/B _2880_/D VPWR VGND sg13cmos5l_nand3_1
XFILLER_31_794 VPWR VGND sg13cmos5l_decap_8
X_1826_ _1870_/B _1861_/A _1862_/B VPWR VGND sg13cmos5l_nor2_1
Xhold401 _3009_/D _2589_/X VPWR VGND sg13cmos5l_dlygate4sd3_1
Xhold434 hold434/X _3035_/Q VPWR VGND sg13cmos5l_dlygate4sd3_1
Xhold445 hold445/X _3086_/Q VPWR VGND sg13cmos5l_dlygate4sd3_1
Xhold412 _2411_/B _2409_/Y VPWR VGND sg13cmos5l_dlygate4sd3_1
Xhold423 _2419_/B _2418_/Y VPWR VGND sg13cmos5l_dlygate4sd3_1
X_1757_ _1762_/B _3130_/Q _3136_/Q VPWR VGND sg13cmos5l_nand2_1
Xhold456 _3018_/D _2606_/Y VPWR VGND sg13cmos5l_dlygate4sd3_1
X_1688_ _1688_/Y _1698_/A _1687_/Y _1681_/A VPWR VGND sg13cmos5l_o21ai_1
X_2309_ _2309_/Y _2309_/A _2309_/B VPWR VGND sg13cmos5l_nor2_1
XFILLER_45_308 VPWR VGND sg13cmos5l_fill_2
XFILLER_45_319 VPWR VGND sg13cmos5l_decap_4
XFILLER_26_511 VPWR VGND sg13cmos5l_fill_2
XFILLER_26_588 VPWR VGND sg13cmos5l_fill_1
XFILLER_16_1014 VPWR VGND sg13cmos5l_decap_8
XFILLER_22_772 VPWR VGND sg13cmos5l_decap_8
XFILLER_10_923 VPWR VGND sg13cmos5l_decap_8
XFILLER_22_783 VPWR VGND sg13cmos5l_fill_1
XFILLER_6_949 VPWR VGND sg13cmos5l_decap_8
XFILLER_5_426 VPWR VGND sg13cmos5l_fill_1
XFILLER_5_448 VPWR VGND sg13cmos5l_fill_1
XFILLER_1_632 VPWR VGND sg13cmos5l_decap_8
XFILLER_49_625 VPWR VGND sg13cmos5l_decap_8
XFILLER_0_186 VPWR VGND sg13cmos5l_decap_8
XFILLER_37_809 VPWR VGND sg13cmos5l_decap_4
XFILLER_45_820 VPWR VGND sg13cmos5l_decap_8
XFILLER_17_511 VPWR VGND sg13cmos5l_fill_1
XFILLER_29_371 VPWR VGND sg13cmos5l_decap_8
XFILLER_29_382 VPWR VGND sg13cmos5l_fill_1
XFILLER_32_514 VPWR VGND sg13cmos5l_decap_8
XFILLER_44_385 VPWR VGND sg13cmos5l_decap_8
XFILLER_32_547 VPWR VGND sg13cmos5l_decap_8
X_2660_ _2660_/Y _2656_/A _2655_/A _2654_/X VPWR VGND sg13cmos5l_o21ai_1
XFILLER_8_253 VPWR VGND sg13cmos5l_fill_1
XFILLER_9_765 VPWR VGND sg13cmos5l_decap_8
XFILLER_12_282 VPWR VGND sg13cmos5l_decap_8
X_1611_ _1611_/Y _1718_/B _1594_/Y _1609_/X VPWR VGND sg13cmos5l_a21oi_1
X_2591_ _2591_/X _3011_/Q hold366/X _2592_/S VPWR VGND sg13cmos5l_mux2_1
XFILLER_5_993 VPWR VGND sg13cmos5l_decap_8
XFILLER_5_53 VPWR VGND sg13cmos5l_decap_8
X_1542_ _1542_/Y _3132_/Q _2183_/B VPWR VGND sg13cmos5l_nor2_1
XFILLER_39_135 VPWR VGND sg13cmos5l_decap_8
XFILLER_36_831 VPWR VGND sg13cmos5l_decap_8
X_3074_ _3074_/Q clkload5/A _3074_/D fanout172/X VPWR VGND sg13cmos5l_dfrbpq_1
XFILLER_47_190 VPWR VGND sg13cmos5l_decap_8
XFILLER_39_1003 VPWR VGND sg13cmos5l_decap_8
XFILLER_35_341 VPWR VGND sg13cmos5l_fill_2
X_2025_ _2025_/Y _2266_/A _2031_/B VPWR VGND sg13cmos5l_nand2_1
X_2927_ _2938_/B _2927_/A _2942_/A VPWR VGND sg13cmos5l_nand2_1
X_2858_ _3064_/D _2857_/A _2886_/A1 _2857_/Y VPWR VGND sg13cmos5l_o21ai_1
X_2789_ _2804_/B _3044_/Q _3060_/Q VPWR VGND sg13cmos5l_xnor2_1
Xhold220 _2431_/B _2430_/Y VPWR VGND sg13cmos5l_dlygate4sd3_1
X_1809_ _1810_/D _2669_/B _3073_/Q VPWR VGND sg13cmos5l_xnor2_1
Xhold231 _1521_/A _2982_/Q VPWR VGND sg13cmos5l_dlygate4sd3_1
Xhold242 _2913_/B _2912_/Y VPWR VGND sg13cmos5l_dlygate4sd3_1
Xhold253 _3025_/D _2626_/Y VPWR VGND sg13cmos5l_dlygate4sd3_1
Xhold286 _3123_/D _2398_/Y VPWR VGND sg13cmos5l_dlygate4sd3_1
Xhold264 _3077_/D _2909_/Y VPWR VGND sg13cmos5l_dlygate4sd3_1
Xhold275 _2976_/D _2481_/Y VPWR VGND sg13cmos5l_dlygate4sd3_1
Xhold297 hold297/X _2490_/Y VPWR VGND sg13cmos5l_dlygate4sd3_1
XFILLER_18_308 VPWR VGND sg13cmos5l_decap_8
Xheichips26_daftASIC_190 uio_oe[2] VPWR VGND sg13cmos5l_tiehi
XFILLER_45_149 VPWR VGND sg13cmos5l_decap_8
XFILLER_42_823 VPWR VGND sg13cmos5l_decap_4
XFILLER_41_311 VPWR VGND sg13cmos5l_decap_8
XFILLER_42_867 VPWR VGND sg13cmos5l_decap_8
XFILLER_10_731 VPWR VGND sg13cmos5l_decap_8
XFILLER_14_95 VPWR VGND sg13cmos5l_decap_4
XFILLER_10_764 VPWR VGND sg13cmos5l_fill_1
XFILLER_10_797 VPWR VGND sg13cmos5l_fill_2
XFILLER_6_746 VPWR VGND sg13cmos5l_decap_8
XFILLER_30_83 VPWR VGND sg13cmos5l_decap_8
XFILLER_2_985 VPWR VGND sg13cmos5l_decap_8
XFILLER_1_484 VPWR VGND sg13cmos5l_fill_2
XFILLER_49_455 VPWR VGND sg13cmos5l_decap_8
XFILLER_39_70 VPWR VGND sg13cmos5l_decap_8
XFILLER_18_831 VPWR VGND sg13cmos5l_fill_2
XFILLER_17_352 VPWR VGND sg13cmos5l_fill_2
XFILLER_33_823 VPWR VGND sg13cmos5l_fill_2
XFILLER_17_396 VPWR VGND sg13cmos5l_decap_8
XFILLER_32_322 VPWR VGND sg13cmos5l_fill_2
XFILLER_33_834 VPWR VGND sg13cmos5l_fill_1
XFILLER_20_506 VPWR VGND sg13cmos5l_decap_8
X_2712_ _2712_/Y _2730_/A1 _1523_/Y _2730_/B1 VPWR VGND sg13cmos5l_a21oi_1
XFILLER_9_573 VPWR VGND sg13cmos5l_fill_2
X_2643_ _2854_/A _1500_/A _2433_/A _2642_/Y VPWR VGND sg13cmos5l_a21oi_1
X_2574_ _2574_/Y _2574_/A _2577_/B VPWR VGND sg13cmos5l_nor2_1
X_1525_ _1525_/Y _1525_/A VPWR VGND sg13cmos5l_inv_1
XFILLER_5_790 VPWR VGND sg13cmos5l_decap_8
XFILLER_19_18 VPWR VGND sg13cmos5l_decap_8
XFILLER_19_29 VPWR VGND sg13cmos5l_fill_2
X_3126_ _3126_/Q clkload5/A _3126_/D fanout177/X VPWR VGND sg13cmos5l_dfrbpq_1
XFILLER_27_127 VPWR VGND sg13cmos5l_decap_8
X_3057_ _3057_/Q _3057_/CLK _3057_/D fanout176/X VPWR VGND sg13cmos5l_dfrbpq_1
XFILLER_24_801 VPWR VGND sg13cmos5l_decap_4
XFILLER_42_119 VPWR VGND sg13cmos5l_decap_4
X_2008_ _2008_/Y _2332_/B _1907_/A _1974_/C VPWR VGND sg13cmos5l_a21oi_1
XFILLER_11_506 VPWR VGND sg13cmos5l_fill_2
XFILLER_24_867 VPWR VGND sg13cmos5l_decap_8
XFILLER_3_749 VPWR VGND sg13cmos5l_decap_8
XFILLER_2_226 VPWR VGND sg13cmos5l_decap_8
XFILLER_47_937 VPWR VGND sg13cmos5l_decap_8
XFILLER_46_414 VPWR VGND sg13cmos5l_decap_8
XFILLER_18_105 VPWR VGND sg13cmos5l_decap_8
XFILLER_19_617 VPWR VGND sg13cmos5l_decap_8
XFILLER_19_639 VPWR VGND sg13cmos5l_fill_2
XFILLER_18_149 VPWR VGND sg13cmos5l_decap_8
XFILLER_27_672 VPWR VGND sg13cmos5l_fill_2
XFILLER_33_108 VPWR VGND sg13cmos5l_decap_8
XFILLER_42_620 VPWR VGND sg13cmos5l_decap_8
XFILLER_14_344 VPWR VGND sg13cmos5l_decap_8
XFILLER_15_867 VPWR VGND sg13cmos5l_decap_8
XFILLER_25_61 VPWR VGND sg13cmos5l_decap_8
XFILLER_30_848 VPWR VGND sg13cmos5l_decap_8
XFILLER_10_561 VPWR VGND sg13cmos5l_decap_4
XFILLER_44_7 VPWR VGND sg13cmos5l_decap_8
X_2290_ _2290_/X _2318_/A _2290_/B _2290_/C VPWR VGND sg13cmos5l_or3_1
XFILLER_2_782 VPWR VGND sg13cmos5l_decap_8
XFILLER_49_296 VPWR VGND sg13cmos5l_decap_8
XFILLER_37_458 VPWR VGND sg13cmos5l_decap_8
XFILLER_37_425 VPWR VGND sg13cmos5l_fill_1
XFILLER_46_981 VPWR VGND sg13cmos5l_decap_8
XFILLER_18_650 VPWR VGND sg13cmos5l_decap_8
XFILLER_45_491 VPWR VGND sg13cmos5l_decap_8
XFILLER_36_1006 VPWR VGND sg13cmos5l_decap_8
XFILLER_21_815 VPWR VGND sg13cmos5l_fill_1
XFILLER_21_848 VPWR VGND sg13cmos5l_decap_8
XFILLER_9_370 VPWR VGND sg13cmos5l_fill_2
XFILLER_9_392 VPWR VGND sg13cmos5l_decap_8
X_2626_ _2626_/Y _2628_/B _2625_/Y _2624_/Y VPWR VGND sg13cmos5l_o21ai_1
X_2557_ _2558_/D _3010_/Q _3011_/Q VPWR VGND sg13cmos5l_nand2_1
XFILLER_0_719 VPWR VGND sg13cmos5l_decap_8
X_1508_ _2920_/A _1508_/A VPWR VGND sg13cmos5l_inv_1
X_2488_ _2488_/Y _2488_/A _2490_/B VPWR VGND sg13cmos5l_nor2_1
Xclkbuf_5_7__f_clk _3091_/CLK clkbuf_4_3_0_clk/X VPWR VGND sg13cmos5l_buf_8
XFILLER_29_937 VPWR VGND sg13cmos5l_decap_8
XFILLER_44_918 VPWR VGND sg13cmos5l_decap_8
X_3109_ _3109_/Q _3119_/CLK _3109_/D fanout150/X VPWR VGND sg13cmos5l_dfrbpq_1
XFILLER_15_119 VPWR VGND sg13cmos5l_decap_4
XFILLER_12_804 VPWR VGND sg13cmos5l_decap_8
XFILLER_24_642 VPWR VGND sg13cmos5l_decap_8
XFILLER_11_325 VPWR VGND sg13cmos5l_decap_8
XFILLER_23_185 VPWR VGND sg13cmos5l_decap_4
XFILLER_7_329 VPWR VGND sg13cmos5l_decap_4
XFILLER_11_369 VPWR VGND sg13cmos5l_fill_1
XFILLER_11_30 VPWR VGND sg13cmos5l_decap_4
XFILLER_3_546 VPWR VGND sg13cmos5l_fill_1
XFILLER_46_200 VPWR VGND sg13cmos5l_fill_2
XFILLER_19_414 VPWR VGND sg13cmos5l_decap_8
XFILLER_35_929 VPWR VGND sg13cmos5l_decap_8
XFILLER_15_620 VPWR VGND sg13cmos5l_fill_2
XFILLER_43_962 VPWR VGND sg13cmos5l_decap_8
XFILLER_15_631 VPWR VGND sg13cmos5l_fill_1
XFILLER_30_612 VPWR VGND sg13cmos5l_decap_8
XFILLER_42_494 VPWR VGND sg13cmos5l_decap_8
XFILLER_30_634 VPWR VGND sg13cmos5l_decap_8
X_1790_ _2925_/A _2442_/A _2442_/B VPWR VGND sg13cmos5l_nor2_1
XFILLER_7_874 VPWR VGND sg13cmos5l_decap_8
XFILLER_6_362 VPWR VGND sg13cmos5l_decap_8
X_2411_ _3109_/D _2594_/B _2411_/B _2413_/B VPWR VGND sg13cmos5l_nor3_1
X_2342_ _2342_/Y _1539_/B _3016_/Q _2340_/Y VPWR VGND sg13cmos5l_o21ai_1
X_2273_ _2273_/Y _2273_/A _2273_/B VPWR VGND sg13cmos5l_nand2_1
XFILLER_38_756 VPWR VGND sg13cmos5l_fill_1
XFILLER_37_233 VPWR VGND sg13cmos5l_fill_2
XFILLER_25_417 VPWR VGND sg13cmos5l_decap_8
XFILLER_25_428 VPWR VGND sg13cmos5l_fill_2
XFILLER_25_439 VPWR VGND sg13cmos5l_decap_4
XFILLER_21_601 VPWR VGND sg13cmos5l_decap_8
XFILLER_34_973 VPWR VGND sg13cmos5l_decap_8
XFILLER_21_678 VPWR VGND sg13cmos5l_decap_8
XFILLER_21_689 VPWR VGND sg13cmos5l_fill_2
X_1988_ _1988_/Y _2196_/A _2251_/A VPWR VGND sg13cmos5l_nor2_1
X_2609_ _2612_/B _2609_/A _2609_/B VPWR VGND sg13cmos5l_nor2_1
XFILLER_0_538 VPWR VGND sg13cmos5l_decap_8
Xclkbuf_4_5_0_clk clkbuf_4_5_0_clk/X clkbuf_0_clk/X VPWR VGND sg13cmos5l_buf_8
XFILLER_28_222 VPWR VGND sg13cmos5l_fill_2
XFILLER_17_907 VPWR VGND sg13cmos5l_decap_8
XFILLER_28_233 VPWR VGND sg13cmos5l_fill_2
XFILLER_29_767 VPWR VGND sg13cmos5l_fill_2
XFILLER_40_954 VPWR VGND sg13cmos5l_decap_8
XFILLER_24_483 VPWR VGND sg13cmos5l_decap_8
XFILLER_24_494 VPWR VGND sg13cmos5l_fill_2
XFILLER_8_616 VPWR VGND sg13cmos5l_decap_8
XFILLER_7_115 VPWR VGND sg13cmos5l_decap_8
XFILLER_4_811 VPWR VGND sg13cmos5l_decap_8
XFILLER_3_354 VPWR VGND sg13cmos5l_decap_4
XFILLER_4_888 VPWR VGND sg13cmos5l_decap_8
XFILLER_3_376 VPWR VGND sg13cmos5l_decap_8
XFILLER_0_0 VPWR VGND sg13cmos5l_decap_8
XFILLER_19_200 VPWR VGND sg13cmos5l_fill_1
XFILLER_19_255 VPWR VGND sg13cmos5l_fill_2
XFILLER_47_586 VPWR VGND sg13cmos5l_decap_8
XFILLER_19_266 VPWR VGND sg13cmos5l_decap_8
XFILLER_19_277 VPWR VGND sg13cmos5l_fill_2
XFILLER_16_951 VPWR VGND sg13cmos5l_decap_8
X_2960_ _2960_/Y _2960_/A _2960_/B VPWR VGND sg13cmos5l_nor2_1
X_1911_ _1982_/A _2196_/A _2251_/A VPWR VGND sg13cmos5l_nand2_1
X_2891_ _2891_/Y _2892_/A _2902_/B VPWR VGND sg13cmos5l_nand2_1
XFILLER_8_20 VPWR VGND sg13cmos5l_decap_8
X_1842_ _1842_/Y _1972_/C _1843_/B _1843_/C VPWR VGND sg13cmos5l_nor3_1
XFILLER_30_464 VPWR VGND sg13cmos5l_decap_8
XFILLER_31_976 VPWR VGND sg13cmos5l_decap_8
XFILLER_8_86 VPWR VGND sg13cmos5l_decap_8
X_1773_ _2597_/C _2331_/A _2605_/A VPWR VGND sg13cmos5l_nor2_1
XFILLER_33_0 VPWR VGND sg13cmos5l_fill_2
X_2325_ _2326_/C _2055_/B _2324_/Y _2370_/A VPWR VGND sg13cmos5l_a21oi_1
X_2256_ _2284_/C _2234_/Y _2255_/Y _2055_/B VPWR VGND sg13cmos5l_o21ai_1
XFILLER_27_18 VPWR VGND sg13cmos5l_decap_8
XFILLER_38_553 VPWR VGND sg13cmos5l_fill_2
X_2187_ _2187_/Y _2187_/A _2187_/B _2317_/B _2187_/D VPWR VGND sg13cmos5l_nand4_1
XFILLER_25_247 VPWR VGND sg13cmos5l_decap_4
XFILLER_22_932 VPWR VGND sg13cmos5l_decap_8
XFILLER_34_792 VPWR VGND sg13cmos5l_decap_4
XFILLER_1_814 VPWR VGND sg13cmos5l_decap_8
XFILLER_49_818 VPWR VGND sg13cmos5l_decap_8
XFILLER_0_357 VPWR VGND sg13cmos5l_decap_8
XFILLER_17_704 VPWR VGND sg13cmos5l_decap_8
XFILLER_29_564 VPWR VGND sg13cmos5l_decap_4
XFILLER_44_545 VPWR VGND sg13cmos5l_decap_8
XFILLER_16_225 VPWR VGND sg13cmos5l_decap_8
XFILLER_17_62 VPWR VGND sg13cmos5l_fill_1
XFILLER_13_932 VPWR VGND sg13cmos5l_decap_8
XFILLER_40_762 VPWR VGND sg13cmos5l_decap_8
XFILLER_12_442 VPWR VGND sg13cmos5l_decap_8
XFILLER_33_50 VPWR VGND sg13cmos5l_decap_8
XFILLER_9_947 VPWR VGND sg13cmos5l_decap_8
XFILLER_4_685 VPWR VGND sg13cmos5l_decap_8
XFILLER_3_184 VPWR VGND sg13cmos5l_fill_1
XFILLER_0_880 VPWR VGND sg13cmos5l_decap_8
X_2110_ _2110_/Y _3020_/Q _2196_/B _2110_/C VPWR VGND sg13cmos5l_nor3_1
X_3090_ _3090_/Q _3091_/CLK _3090_/D fanout160/X VPWR VGND sg13cmos5l_dfrbpq_1
XFILLER_48_851 VPWR VGND sg13cmos5l_decap_8
X_2041_ _2601_/A _2244_/A _2041_/B VPWR VGND sg13cmos5l_nand2_1
XFILLER_35_501 VPWR VGND sg13cmos5l_decap_8
X_2943_ _2952_/A _3038_/Q _2943_/B VPWR VGND sg13cmos5l_xnor2_1
X_2874_ _2874_/Y _2875_/B _2879_/B VPWR VGND sg13cmos5l_nand2_1
XFILLER_31_784 VPWR VGND sg13cmos5l_fill_1
X_1825_ _2332_/B _2602_/A _1862_/A VPWR VGND sg13cmos5l_nand2_1
Xhold402 hold402/X _3008_/Q VPWR VGND sg13cmos5l_dlygate4sd3_1
XFILLER_8_991 VPWR VGND sg13cmos5l_decap_8
X_1756_ _1756_/Y _2332_/A _1755_/Y _1754_/X VPWR VGND sg13cmos5l_o21ai_1
Xhold435 _1509_/A _3034_/Q VPWR VGND sg13cmos5l_dlygate4sd3_1
Xhold413 _2498_/A _2998_/Q VPWR VGND sg13cmos5l_dlygate4sd3_1
Xhold424 _3112_/D _2419_/Y VPWR VGND sg13cmos5l_dlygate4sd3_1
Xhold446 _3086_/D _2964_/X VPWR VGND sg13cmos5l_dlygate4sd3_1
Xhold457 hold457/X _3106_/Q VPWR VGND sg13cmos5l_dlygate4sd3_1
X_1687_ _1687_/Y _1726_/C _1687_/B VPWR VGND sg13cmos5l_nor2_1
X_2308_ _2309_/B _2308_/A _2308_/B _2308_/C _2308_/D VPWR VGND sg13cmos5l_nor4_1
XFILLER_39_884 VPWR VGND sg13cmos5l_decap_8
X_2239_ _2239_/X _2212_/B _2238_/Y _2237_/Y VPWR VGND sg13cmos5l_a21o_1
XFILLER_13_239 VPWR VGND sg13cmos5l_decap_8
XFILLER_10_902 VPWR VGND sg13cmos5l_decap_8
XFILLER_6_928 VPWR VGND sg13cmos5l_decap_8
XFILLER_10_979 VPWR VGND sg13cmos5l_decap_8
XFILLER_1_611 VPWR VGND sg13cmos5l_decap_8
XFILLER_49_604 VPWR VGND sg13cmos5l_decap_8
XFILLER_0_165 VPWR VGND sg13cmos5l_decap_8
XFILLER_1_688 VPWR VGND sg13cmos5l_decap_8
XFILLER_48_136 VPWR VGND sg13cmos5l_decap_8
XFILLER_17_534 VPWR VGND sg13cmos5l_decap_4
XFILLER_17_545 VPWR VGND sg13cmos5l_decap_4
XFILLER_45_898 VPWR VGND sg13cmos5l_decap_8
XFILLER_44_364 VPWR VGND sg13cmos5l_decap_8
XFILLER_9_744 VPWR VGND sg13cmos5l_decap_8
XFILLER_12_250 VPWR VGND sg13cmos5l_decap_8
X_1610_ _1613_/C _1632_/A _1610_/B VPWR VGND sg13cmos5l_nand2_1
X_2590_ _2590_/X _3010_/Q hold407/X _2592_/S VPWR VGND sg13cmos5l_mux2_1
XFILLER_5_972 VPWR VGND sg13cmos5l_decap_8
X_1541_ _1541_/Y _3133_/Q _2605_/B VPWR VGND sg13cmos5l_nand2b_1
XFILLER_39_114 VPWR VGND sg13cmos5l_decap_8
XFILLER_36_810 VPWR VGND sg13cmos5l_decap_8
X_3073_ _3073_/Q _3134_/CLK _3073_/D fanout172/X VPWR VGND sg13cmos5l_dfrbpq_1
XFILLER_35_320 VPWR VGND sg13cmos5l_decap_8
X_2024_ _2028_/C _2047_/C _2086_/B _2024_/C VPWR VGND sg13cmos5l_nor3_1
XFILLER_36_887 VPWR VGND sg13cmos5l_decap_8
X_2926_ _2926_/Y _1800_/A _2919_/A _2669_/B VPWR VGND sg13cmos5l_a21oi_1
X_2857_ _2857_/Y _2857_/A _2879_/B VPWR VGND sg13cmos5l_nand2_1
XFILLER_31_592 VPWR VGND sg13cmos5l_decap_8
X_1808_ _1810_/C _3075_/Q _3074_/Q _1808_/C VPWR VGND sg13cmos5l_nor3_1
X_2788_ _2802_/A _3037_/Q _2824_/A VPWR VGND sg13cmos5l_xnor2_1
Xhold210 _2379_/C _2378_/Y VPWR VGND sg13cmos5l_dlygate4sd3_1
Xhold232 _2518_/A _2981_/Q VPWR VGND sg13cmos5l_dlygate4sd3_1
XFILLER_2_419 VPWR VGND sg13cmos5l_fill_1
X_1739_ _1740_/C _1817_/A _1739_/B _1739_/C VPWR VGND sg13cmos5l_nand3_1
Xhold221 _3091_/D _2431_/Y VPWR VGND sg13cmos5l_dlygate4sd3_1
Xhold243 _3078_/D _2913_/Y VPWR VGND sg13cmos5l_dlygate4sd3_1
Xhold254 _1524_/A _2986_/Q VPWR VGND sg13cmos5l_dlygate4sd3_1
Xhold287 _2494_/B _3001_/Q VPWR VGND sg13cmos5l_dlygate4sd3_1
Xhold276 _2863_/C _3066_/Q VPWR VGND sg13cmos5l_dlygate4sd3_1
Xhold265 _2456_/A _2970_/Q VPWR VGND sg13cmos5l_dlygate4sd3_1
Xhold298 _2980_/D _2491_/Y VPWR VGND sg13cmos5l_dlygate4sd3_1
Xheichips26_daftASIC_180 uio_out[2] VPWR VGND sg13cmos5l_tielo
Xheichips26_daftASIC_191 uio_oe[3] VPWR VGND sg13cmos5l_tiehi
XFILLER_27_810 VPWR VGND sg13cmos5l_decap_8
XFILLER_45_128 VPWR VGND sg13cmos5l_decap_8
XFILLER_38_180 VPWR VGND sg13cmos5l_decap_8
XFILLER_27_843 VPWR VGND sg13cmos5l_decap_4
XFILLER_42_802 VPWR VGND sg13cmos5l_decap_8
XFILLER_42_846 VPWR VGND sg13cmos5l_decap_4
XFILLER_26_397 VPWR VGND sg13cmos5l_decap_8
XFILLER_41_367 VPWR VGND sg13cmos5l_fill_1
XFILLER_41_389 VPWR VGND sg13cmos5l_decap_8
XFILLER_10_754 VPWR VGND sg13cmos5l_fill_1
XFILLER_6_725 VPWR VGND sg13cmos5l_decap_8
XFILLER_5_202 VPWR VGND sg13cmos5l_decap_8
XFILLER_5_279 VPWR VGND sg13cmos5l_decap_8
XFILLER_2_964 VPWR VGND sg13cmos5l_decap_8
XFILLER_49_434 VPWR VGND sg13cmos5l_decap_8
XFILLER_18_810 VPWR VGND sg13cmos5l_fill_2
XFILLER_44_150 VPWR VGND sg13cmos5l_fill_1
XFILLER_17_342 VPWR VGND sg13cmos5l_fill_1
XFILLER_18_887 VPWR VGND sg13cmos5l_decap_8
XFILLER_33_802 VPWR VGND sg13cmos5l_decap_8
XFILLER_32_301 VPWR VGND sg13cmos5l_decap_8
XFILLER_33_879 VPWR VGND sg13cmos5l_decap_8
XFILLER_20_529 VPWR VGND sg13cmos5l_decap_8
X_2711_ _2711_/Y _2726_/B _2710_/X _2856_/B VPWR VGND sg13cmos5l_o21ai_1
XFILLER_9_552 VPWR VGND sg13cmos5l_decap_8
XFILLER_9_596 VPWR VGND sg13cmos5l_decap_8
X_2642_ _2642_/Y _2850_/A _3063_/Q _2851_/B VPWR VGND sg13cmos5l_nor3_1
X_2573_ _2573_/Y _2511_/A _2577_/B _2572_/Y VPWR VGND sg13cmos5l_a21oi_1
X_1524_ _1524_/Y _1524_/A VPWR VGND sg13cmos5l_inv_1
X_3125_ _3125_/Q _3129_/CLK _3125_/D fanout174/X VPWR VGND sg13cmos5l_dfrbpq_1
XFILLER_28_629 VPWR VGND sg13cmos5l_fill_1
X_3056_ _3056_/Q _3060_/CLK _3056_/D fanout173/X VPWR VGND sg13cmos5l_dfrbpq_1
X_2007_ _2007_/Y _2280_/A _1994_/Y _2006_/Y VPWR VGND sg13cmos5l_o21ai_1
XFILLER_24_846 VPWR VGND sg13cmos5l_decap_8
XFILLER_23_367 VPWR VGND sg13cmos5l_decap_4
XFILLER_23_378 VPWR VGND sg13cmos5l_fill_2
X_2909_ _2909_/Y _2914_/D _2908_/Y _2906_/Y VPWR VGND sg13cmos5l_o21ai_1
XFILLER_3_728 VPWR VGND sg13cmos5l_decap_8
XFILLER_2_205 VPWR VGND sg13cmos5l_decap_8
XFILLER_47_916 VPWR VGND sg13cmos5l_decap_8
XFILLER_46_426 VPWR VGND sg13cmos5l_fill_2
XFILLER_18_128 VPWR VGND sg13cmos5l_fill_2
XFILLER_27_640 VPWR VGND sg13cmos5l_decap_4
XFILLER_15_846 VPWR VGND sg13cmos5l_decap_8
XFILLER_14_323 VPWR VGND sg13cmos5l_fill_2
XFILLER_15_879 VPWR VGND sg13cmos5l_decap_8
XFILLER_25_40 VPWR VGND sg13cmos5l_decap_8
XFILLER_30_827 VPWR VGND sg13cmos5l_decap_8
XFILLER_23_890 VPWR VGND sg13cmos5l_fill_1
XFILLER_6_500 VPWR VGND sg13cmos5l_fill_2
XFILLER_10_540 VPWR VGND sg13cmos5l_fill_2
XFILLER_6_555 VPWR VGND sg13cmos5l_fill_2
XFILLER_6_588 VPWR VGND sg13cmos5l_decap_8
XFILLER_29_1014 VPWR VGND sg13cmos5l_decap_8
XFILLER_2_761 VPWR VGND sg13cmos5l_decap_8
XFILLER_2_11 VPWR VGND sg13cmos5l_decap_4
XFILLER_49_275 VPWR VGND sg13cmos5l_decap_8
XFILLER_2_88 VPWR VGND sg13cmos5l_fill_2
XFILLER_2_99 VPWR VGND sg13cmos5l_fill_2
XFILLER_46_960 VPWR VGND sg13cmos5l_decap_8
XFILLER_17_161 VPWR VGND sg13cmos5l_decap_8
XFILLER_20_304 VPWR VGND sg13cmos5l_decap_8
XFILLER_21_827 VPWR VGND sg13cmos5l_decap_8
XFILLER_32_197 VPWR VGND sg13cmos5l_fill_2
X_2625_ _2625_/Y _2635_/A _2630_/B _2621_/A VPWR VGND sg13cmos5l_a21oi_1
X_2556_ _2558_/C _3008_/Q _3009_/Q _2556_/C VPWR VGND sg13cmos5l_nand3_1
X_1507_ _2810_/C _1507_/A VPWR VGND sg13cmos5l_inv_1
X_2487_ _2487_/Y _2486_/B _2485_/Y hold279/X VPWR VGND sg13cmos5l_a21oi_1
XFILLER_29_916 VPWR VGND sg13cmos5l_decap_8
XFILLER_46_39 VPWR VGND sg13cmos5l_decap_4
X_3108_ _3108_/Q _3119_/CLK _3108_/D fanout149/X VPWR VGND sg13cmos5l_dfrbpq_1
X_3039_ _3039_/Q _3050_/CLK _3039_/D fanout171/X VPWR VGND sg13cmos5l_dfrbpq_1
XFILLER_37_982 VPWR VGND sg13cmos5l_decap_8
XFILLER_24_621 VPWR VGND sg13cmos5l_decap_8
XFILLER_8_809 VPWR VGND sg13cmos5l_decap_8
XFILLER_23_197 VPWR VGND sg13cmos5l_fill_1
XFILLER_20_871 VPWR VGND sg13cmos5l_decap_4
XFILLER_20_882 VPWR VGND sg13cmos5l_fill_1
XFILLER_3_536 VPWR VGND sg13cmos5l_fill_2
XFILLER_3_525 VPWR VGND sg13cmos5l_decap_8
XFILLER_11_64 VPWR VGND sg13cmos5l_decap_8
XFILLER_2_4 VPWR VGND sg13cmos5l_decap_8
XFILLER_47_746 VPWR VGND sg13cmos5l_decap_8
XFILLER_35_908 VPWR VGND sg13cmos5l_decap_8
XFILLER_46_278 VPWR VGND sg13cmos5l_decap_8
XFILLER_36_50 VPWR VGND sg13cmos5l_decap_8
XFILLER_27_481 VPWR VGND sg13cmos5l_decap_8
XFILLER_28_993 VPWR VGND sg13cmos5l_decap_8
XFILLER_43_941 VPWR VGND sg13cmos5l_decap_8
XFILLER_36_83 VPWR VGND sg13cmos5l_decap_8
XFILLER_14_131 VPWR VGND sg13cmos5l_decap_8
XFILLER_15_654 VPWR VGND sg13cmos5l_decap_4
XFILLER_42_473 VPWR VGND sg13cmos5l_decap_8
XFILLER_14_186 VPWR VGND sg13cmos5l_decap_4
XFILLER_30_657 VPWR VGND sg13cmos5l_decap_8
XFILLER_30_668 VPWR VGND sg13cmos5l_fill_1
XFILLER_10_370 VPWR VGND sg13cmos5l_fill_2
XFILLER_7_853 VPWR VGND sg13cmos5l_decap_8
XFILLER_6_396 VPWR VGND sg13cmos5l_decap_8
X_2410_ _2413_/B _2412_/A _2412_/C _2410_/C VPWR VGND sg13cmos5l_and3_1
X_2341_ _2341_/Y _3019_/Q _1831_/C _2609_/A VPWR VGND sg13cmos5l_o21ai_1
X_2272_ _2273_/B _2229_/B _2272_/B _2272_/C VPWR VGND sg13cmos5l_nand3b_1
XFILLER_42_1022 VPWR VGND sg13cmos5l_decap_8
XFILLER_38_735 VPWR VGND sg13cmos5l_decap_8
XFILLER_37_212 VPWR VGND sg13cmos5l_decap_8
XFILLER_37_201 VPWR VGND sg13cmos5l_fill_2
XFILLER_19_993 VPWR VGND sg13cmos5l_decap_8
XFILLER_34_952 VPWR VGND sg13cmos5l_decap_8
X_1987_ _1987_/Y _2212_/B _1987_/B VPWR VGND sg13cmos5l_nand2_1
XFILLER_20_156 VPWR VGND sg13cmos5l_fill_1
XFILLER_21_657 VPWR VGND sg13cmos5l_decap_8
X_2608_ _2610_/B _2332_/C _2603_/B _2596_/C VPWR VGND sg13cmos5l_a21oi_1
X_2539_ _2568_/A _2537_/Y _2539_/B VPWR VGND sg13cmos5l_nand2b_1
XFILLER_0_517 VPWR VGND sg13cmos5l_decap_8
XFILLER_29_724 VPWR VGND sg13cmos5l_decap_4
XFILLER_29_746 VPWR VGND sg13cmos5l_decap_8
XFILLER_44_716 VPWR VGND sg13cmos5l_decap_8
XFILLER_43_237 VPWR VGND sg13cmos5l_fill_2
XFILLER_37_790 VPWR VGND sg13cmos5l_decap_8
XFILLER_24_451 VPWR VGND sg13cmos5l_decap_8
XFILLER_24_462 VPWR VGND sg13cmos5l_fill_2
XFILLER_25_985 VPWR VGND sg13cmos5l_decap_8
XFILLER_40_933 VPWR VGND sg13cmos5l_decap_8
XFILLER_11_123 VPWR VGND sg13cmos5l_decap_8
XFILLER_8_639 VPWR VGND sg13cmos5l_decap_8
XFILLER_4_867 VPWR VGND sg13cmos5l_decap_8
XFILLER_3_333 VPWR VGND sg13cmos5l_decap_8
XFILLER_3_322 VPWR VGND sg13cmos5l_decap_8
XFILLER_26_1028 VPWR VGND sg13cmos5l_fill_1
XFILLER_47_521 VPWR VGND sg13cmos5l_decap_8
XFILLER_19_234 VPWR VGND sg13cmos5l_decap_8
XFILLER_19_289 VPWR VGND sg13cmos5l_decap_8
XFILLER_16_930 VPWR VGND sg13cmos5l_decap_8
XFILLER_34_226 VPWR VGND sg13cmos5l_decap_8
X_1910_ _2231_/A _2268_/A _1985_/B VPWR VGND sg13cmos5l_nor2_1
XFILLER_30_410 VPWR VGND sg13cmos5l_decap_8
X_2890_ _2890_/Y _2896_/A _2889_/Y _2887_/Y VPWR VGND sg13cmos5l_o21ai_1
XFILLER_31_955 VPWR VGND sg13cmos5l_decap_8
X_1841_ _2074_/A _1972_/C _1843_/B VPWR VGND sg13cmos5l_nor2_1
XFILLER_8_65 VPWR VGND sg13cmos5l_decap_8
XFILLER_11_690 VPWR VGND sg13cmos5l_decap_8
X_1772_ _3124_/D _1702_/Y _1704_/Y _1743_/X _1823_/A _2339_/B VPWR VGND sg13cmos5l_a221oi_1
XFILLER_6_193 VPWR VGND sg13cmos5l_decap_8
X_2324_ _2324_/Y _2322_/Y _2323_/Y _2158_/B VPWR VGND sg13cmos5l_o21ai_1
XFILLER_38_510 VPWR VGND sg13cmos5l_fill_1
X_2255_ _2255_/Y _2282_/A _2254_/Y _2250_/Y VPWR VGND sg13cmos5l_o21ai_1
X_2186_ _2187_/D _2029_/B _2186_/B _2186_/C VPWR VGND sg13cmos5l_nand3b_1
XFILLER_26_727 VPWR VGND sg13cmos5l_decap_8
XFILLER_26_738 VPWR VGND sg13cmos5l_fill_2
XFILLER_26_749 VPWR VGND sg13cmos5l_decap_8
XFILLER_22_911 VPWR VGND sg13cmos5l_decap_8
XFILLER_34_771 VPWR VGND sg13cmos5l_decap_8
XFILLER_22_988 VPWR VGND sg13cmos5l_decap_8
XFILLER_21_465 VPWR VGND sg13cmos5l_fill_2
XFILLER_49_1028 VPWR VGND sg13cmos5l_fill_1
XFILLER_0_336 VPWR VGND sg13cmos5l_decap_8
XFILLER_29_543 VPWR VGND sg13cmos5l_decap_8
XFILLER_44_524 VPWR VGND sg13cmos5l_decap_8
XFILLER_13_911 VPWR VGND sg13cmos5l_decap_8
XFILLER_25_771 VPWR VGND sg13cmos5l_decap_8
XFILLER_31_207 VPWR VGND sg13cmos5l_decap_8
XFILLER_12_421 VPWR VGND sg13cmos5l_fill_2
XFILLER_31_218 VPWR VGND sg13cmos5l_fill_1
XFILLER_40_741 VPWR VGND sg13cmos5l_fill_1
XFILLER_9_926 VPWR VGND sg13cmos5l_decap_8
XFILLER_8_436 VPWR VGND sg13cmos5l_decap_8
XFILLER_13_988 VPWR VGND sg13cmos5l_decap_8
XFILLER_12_498 VPWR VGND sg13cmos5l_decap_8
XFILLER_4_664 VPWR VGND sg13cmos5l_decap_8
XFILLER_3_130 VPWR VGND sg13cmos5l_fill_1
XFILLER_3_196 VPWR VGND sg13cmos5l_fill_2
XFILLER_48_830 VPWR VGND sg13cmos5l_decap_8
XFILLER_12_6 VPWR VGND sg13cmos5l_fill_1
X_2040_ _2051_/B _2035_/Y _2039_/Y _2231_/A VPWR VGND sg13cmos5l_o21ai_1
XFILLER_35_546 VPWR VGND sg13cmos5l_fill_1
XFILLER_35_535 VPWR VGND sg13cmos5l_decap_8
X_2942_ _2950_/B _2942_/A _2942_/B VPWR VGND sg13cmos5l_nand2_1
XFILLER_22_229 VPWR VGND sg13cmos5l_decap_8
XFILLER_31_752 VPWR VGND sg13cmos5l_decap_8
X_2873_ _2873_/Y _2886_/A1 _2872_/Y _2871_/Y VPWR VGND sg13cmos5l_o21ai_1
Xclkbuf_4_4_0_clk clkbuf_4_4_0_clk/X clkbuf_0_clk/X VPWR VGND sg13cmos5l_buf_8
X_1824_ _3129_/D _2339_/B _1824_/B VPWR VGND sg13cmos5l_nor2_1
XFILLER_8_970 VPWR VGND sg13cmos5l_decap_8
X_1755_ _1755_/Y _1755_/A _1755_/B VPWR VGND sg13cmos5l_xnor2_1
Xhold436 _1506_/A _3032_/Q VPWR VGND sg13cmos5l_dlygate4sd3_1
Xhold414 _2965_/B _2500_/B VPWR VGND sg13cmos5l_dlygate4sd3_1
Xhold403 hold403/X _3080_/Q VPWR VGND sg13cmos5l_dlygate4sd3_1
Xhold425 _2371_/B _3113_/Q VPWR VGND sg13cmos5l_dlygate4sd3_1
Xhold458 _2503_/A _2995_/Q VPWR VGND sg13cmos5l_dlygate4sd3_1
X_1686_ _1686_/Y _1690_/B _1708_/B _2362_/A VPWR VGND sg13cmos5l_a21oi_1
Xhold447 hold447/X _3121_/Q VPWR VGND sg13cmos5l_dlygate4sd3_1
X_2307_ _2326_/B _2098_/A _2306_/Y _2404_/B VPWR VGND sg13cmos5l_o21ai_1
XFILLER_39_863 VPWR VGND sg13cmos5l_decap_8
X_2238_ _2238_/Y _2190_/C _2178_/A _1913_/B VPWR VGND sg13cmos5l_o21ai_1
XFILLER_38_384 VPWR VGND sg13cmos5l_decap_8
X_2169_ _2169_/Y _2194_/A _2169_/B VPWR VGND sg13cmos5l_nand2_1
XFILLER_14_708 VPWR VGND sg13cmos5l_decap_8
XFILLER_26_568 VPWR VGND sg13cmos5l_decap_8
XFILLER_26_579 VPWR VGND sg13cmos5l_fill_1
XFILLER_41_538 VPWR VGND sg13cmos5l_decap_8
XFILLER_13_218 VPWR VGND sg13cmos5l_decap_8
XFILLER_6_907 VPWR VGND sg13cmos5l_decap_8
XFILLER_10_958 VPWR VGND sg13cmos5l_decap_8
XFILLER_21_284 VPWR VGND sg13cmos5l_fill_2
XFILLER_5_406 VPWR VGND sg13cmos5l_decap_8
XFILLER_0_144 VPWR VGND sg13cmos5l_decap_8
XFILLER_1_667 VPWR VGND sg13cmos5l_decap_8
XFILLER_23_1009 VPWR VGND sg13cmos5l_decap_8
XFILLER_17_502 VPWR VGND sg13cmos5l_decap_8
XFILLER_28_84 VPWR VGND sg13cmos5l_decap_8
XFILLER_29_395 VPWR VGND sg13cmos5l_decap_8
XFILLER_45_877 VPWR VGND sg13cmos5l_decap_8
XFILLER_44_343 VPWR VGND sg13cmos5l_decap_8
XFILLER_17_557 VPWR VGND sg13cmos5l_decap_4
XFILLER_17_579 VPWR VGND sg13cmos5l_decap_8
XFILLER_40_571 VPWR VGND sg13cmos5l_decap_4
XFILLER_9_723 VPWR VGND sg13cmos5l_decap_8
XFILLER_13_763 VPWR VGND sg13cmos5l_decap_8
XFILLER_13_785 VPWR VGND sg13cmos5l_decap_8
XFILLER_8_244 VPWR VGND sg13cmos5l_decap_8
XFILLER_8_233 VPWR VGND sg13cmos5l_decap_8
XFILLER_8_266 VPWR VGND sg13cmos5l_decap_8
XFILLER_5_951 VPWR VGND sg13cmos5l_decap_8
X_1540_ _1571_/A _1538_/Y _1540_/B VPWR VGND sg13cmos5l_nand2b_1
X_3072_ _3072_/Q _3072_/CLK _3072_/D fanout172/X VPWR VGND sg13cmos5l_dfrbpq_1
X_2023_ _2024_/C _2023_/A VPWR VGND sg13cmos5l_inv_1
XFILLER_36_866 VPWR VGND sg13cmos5l_decap_8
XFILLER_23_505 VPWR VGND sg13cmos5l_decap_8
XFILLER_35_398 VPWR VGND sg13cmos5l_decap_8
XFILLER_23_549 VPWR VGND sg13cmos5l_decap_8
X_2925_ _2948_/B _2925_/A _2686_/C VPWR VGND sg13cmos5l_nor2b_1
XFILLER_31_571 VPWR VGND sg13cmos5l_fill_1
X_2856_ _2856_/Y _2879_/B _2856_/B VPWR VGND sg13cmos5l_nand2b_1
X_1807_ _1812_/D _2885_/A _1807_/B VPWR VGND sg13cmos5l_xnor2_1
X_2787_ _2804_/A _3038_/Q _2827_/A VPWR VGND sg13cmos5l_xnor2_1
Xhold200 _3099_/D _3098_/Q VPWR VGND sg13cmos5l_dlygate4sd3_1
Xhold211 _3116_/D _2379_/Y VPWR VGND sg13cmos5l_dlygate4sd3_1
Xhold233 _2981_/D _2519_/Y VPWR VGND sg13cmos5l_dlygate4sd3_1
X_1738_ _1740_/B _1738_/A _1738_/B _1738_/C VPWR VGND sg13cmos5l_nand3_1
Xhold244 _2472_/A _2974_/Q VPWR VGND sg13cmos5l_dlygate4sd3_1
Xhold222 _2851_/A _3063_/Q VPWR VGND sg13cmos5l_dlygate4sd3_1
Xhold255 _2986_/D _2530_/Y VPWR VGND sg13cmos5l_dlygate4sd3_1
XFILLER_46_1009 VPWR VGND sg13cmos5l_decap_8
X_1669_ _1669_/Y _1733_/B _1738_/B VPWR VGND sg13cmos5l_nor2_1
Xhold277 _3066_/D _2866_/Y VPWR VGND sg13cmos5l_dlygate4sd3_1
Xhold266 _2970_/D _2457_/Y VPWR VGND sg13cmos5l_dlygate4sd3_1
Xhold288 _3001_/D _2581_/X VPWR VGND sg13cmos5l_dlygate4sd3_1
Xhold299 _1523_/A _2985_/Q VPWR VGND sg13cmos5l_dlygate4sd3_1
Xheichips26_daftASIC_181 uio_out[3] VPWR VGND sg13cmos5l_tielo
Xheichips26_daftASIC_192 uio_oe[4] VPWR VGND sg13cmos5l_tiehi
XFILLER_39_682 VPWR VGND sg13cmos5l_fill_2
XFILLER_26_332 VPWR VGND sg13cmos5l_decap_8
XFILLER_14_527 VPWR VGND sg13cmos5l_decap_8
XFILLER_14_538 VPWR VGND sg13cmos5l_fill_2
XFILLER_26_376 VPWR VGND sg13cmos5l_decap_8
XFILLER_27_899 VPWR VGND sg13cmos5l_decap_8
XFILLER_14_42 VPWR VGND sg13cmos5l_fill_1
XFILLER_14_75 VPWR VGND sg13cmos5l_fill_2
XFILLER_6_704 VPWR VGND sg13cmos5l_decap_8
XFILLER_5_225 VPWR VGND sg13cmos5l_decap_8
XFILLER_5_258 VPWR VGND sg13cmos5l_decap_8
XFILLER_30_63 VPWR VGND sg13cmos5l_decap_4
XFILLER_2_943 VPWR VGND sg13cmos5l_decap_8
XFILLER_1_453 VPWR VGND sg13cmos5l_decap_8
XFILLER_49_413 VPWR VGND sg13cmos5l_decap_8
XFILLER_7_1014 VPWR VGND sg13cmos5l_decap_8
XFILLER_36_129 VPWR VGND sg13cmos5l_decap_8
XFILLER_18_866 VPWR VGND sg13cmos5l_decap_8
XFILLER_33_825 VPWR VGND sg13cmos5l_fill_1
XFILLER_44_184 VPWR VGND sg13cmos5l_decap_8
XFILLER_32_324 VPWR VGND sg13cmos5l_fill_1
XFILLER_33_858 VPWR VGND sg13cmos5l_decap_8
X_2710_ _2710_/X _2710_/A _2710_/B VPWR VGND sg13cmos5l_and2_1
XFILLER_9_531 VPWR VGND sg13cmos5l_decap_8
XFILLER_9_586 VPWR VGND sg13cmos5l_fill_1
X_2641_ _2851_/B _2641_/A _2641_/B _2641_/C _2641_/D VPWR VGND sg13cmos5l_or4_1
X_2572_ _2572_/Y _2572_/A _2577_/B VPWR VGND sg13cmos5l_nor2_1
X_1523_ _1523_/Y _1523_/A VPWR VGND sg13cmos5l_inv_1
X_3124_ _3124_/Q _3134_/CLK _3124_/D fanout177/X VPWR VGND sg13cmos5l_dfrbpq_1
X_3055_ _3055_/Q _3060_/CLK _3055_/D fanout175/X VPWR VGND sg13cmos5l_dfrbpq_1
X_2006_ _2006_/Y _2001_/Y _2005_/Y _2263_/A VPWR VGND sg13cmos5l_a21oi_1
XFILLER_24_825 VPWR VGND sg13cmos5l_decap_4
XFILLER_23_335 VPWR VGND sg13cmos5l_decap_8
X_2908_ _2908_/Y _2907_/A _2907_/B _2914_/C VPWR VGND sg13cmos5l_o21ai_1
X_2839_ _2842_/B _2839_/A _2839_/B VPWR VGND sg13cmos5l_and2_1
XFILLER_3_707 VPWR VGND sg13cmos5l_decap_8
XFILLER_4_8 VPWR VGND sg13cmos5l_decap_8
XFILLER_15_825 VPWR VGND sg13cmos5l_decap_8
XFILLER_42_655 VPWR VGND sg13cmos5l_fill_2
XFILLER_25_96 VPWR VGND sg13cmos5l_decap_8
XFILLER_30_806 VPWR VGND sg13cmos5l_decap_8
XFILLER_6_534 VPWR VGND sg13cmos5l_decap_8
XFILLER_6_567 VPWR VGND sg13cmos5l_decap_8
XFILLER_2_740 VPWR VGND sg13cmos5l_decap_8
XFILLER_49_232 VPWR VGND sg13cmos5l_fill_1
XFILLER_38_939 VPWR VGND sg13cmos5l_decap_8
XFILLER_2_45 VPWR VGND sg13cmos5l_decap_4
XFILLER_37_438 VPWR VGND sg13cmos5l_decap_8
XFILLER_45_460 VPWR VGND sg13cmos5l_fill_1
XFILLER_18_696 VPWR VGND sg13cmos5l_decap_8
XFILLER_33_622 VPWR VGND sg13cmos5l_decap_8
XFILLER_17_195 VPWR VGND sg13cmos5l_decap_4
XFILLER_21_806 VPWR VGND sg13cmos5l_decap_8
XFILLER_14_891 VPWR VGND sg13cmos5l_decap_8
XFILLER_20_338 VPWR VGND sg13cmos5l_fill_2
XFILLER_32_176 VPWR VGND sg13cmos5l_decap_8
XFILLER_33_699 VPWR VGND sg13cmos5l_decap_8
XFILLER_9_372 VPWR VGND sg13cmos5l_fill_1
X_2624_ _2624_/Y _2628_/A _2628_/B VPWR VGND sg13cmos5l_nand2_1
X_2555_ _2556_/C _3005_/Q _3004_/Q VPWR VGND sg13cmos5l_nor2_1
X_1506_ _2664_/A _1506_/A VPWR VGND sg13cmos5l_inv_1
X_2486_ _2486_/Y _2486_/A _2486_/B VPWR VGND sg13cmos5l_nor2_1
X_3107_ _3107_/Q clkload0/A _3107_/D fanout149/X VPWR VGND sg13cmos5l_dfrbpq_1
XFILLER_28_438 VPWR VGND sg13cmos5l_fill_1
XFILLER_37_961 VPWR VGND sg13cmos5l_decap_8
X_3038_ _3038_/Q _3050_/CLK _3038_/D fanout170/X VPWR VGND sg13cmos5l_dfrbpq_1
XFILLER_11_338 VPWR VGND sg13cmos5l_decap_8
XFILLER_12_839 VPWR VGND sg13cmos5l_decap_8
XFILLER_11_43 VPWR VGND sg13cmos5l_decap_8
XFILLER_3_559 VPWR VGND sg13cmos5l_decap_8
XFILLER_47_736 VPWR VGND sg13cmos5l_fill_1
XFILLER_46_224 VPWR VGND sg13cmos5l_decap_8
XFILLER_4_1028 VPWR VGND sg13cmos5l_fill_1
XFILLER_46_257 VPWR VGND sg13cmos5l_decap_8
XFILLER_19_449 VPWR VGND sg13cmos5l_fill_2
XFILLER_43_920 VPWR VGND sg13cmos5l_decap_8
XFILLER_27_460 VPWR VGND sg13cmos5l_decap_8
XFILLER_28_972 VPWR VGND sg13cmos5l_decap_8
XFILLER_15_622 VPWR VGND sg13cmos5l_fill_1
XFILLER_43_997 VPWR VGND sg13cmos5l_decap_8
XFILLER_42_452 VPWR VGND sg13cmos5l_decap_8
XFILLER_15_699 VPWR VGND sg13cmos5l_decap_8
XFILLER_7_832 VPWR VGND sg13cmos5l_decap_8
XFILLER_11_894 VPWR VGND sg13cmos5l_decap_8
XFILLER_6_353 VPWR VGND sg13cmos5l_decap_4
XFILLER_6_386 VPWR VGND sg13cmos5l_decap_4
X_2340_ _2340_/Y _1539_/B _2246_/A _1775_/C VPWR VGND sg13cmos5l_a21oi_1
XFILLER_42_1001 VPWR VGND sg13cmos5l_decap_8
X_2271_ _2272_/B _2131_/C _2257_/Y _2270_/Y _2181_/Y VPWR VGND sg13cmos5l_a22oi_1
XFILLER_38_714 VPWR VGND sg13cmos5l_decap_8
XFILLER_46_780 VPWR VGND sg13cmos5l_fill_2
XFILLER_37_279 VPWR VGND sg13cmos5l_fill_1
XFILLER_19_972 VPWR VGND sg13cmos5l_decap_8
XFILLER_45_290 VPWR VGND sg13cmos5l_decap_8
XFILLER_34_931 VPWR VGND sg13cmos5l_decap_8
XFILLER_21_636 VPWR VGND sg13cmos5l_decap_8
X_1986_ _1987_/B _2240_/B _2251_/B _1953_/Y VPWR VGND sg13cmos5l_o21ai_1
XFILLER_20_135 VPWR VGND sg13cmos5l_decap_8
XFILLER_20_168 VPWR VGND sg13cmos5l_decap_8
Xclkbuf_5_15__f_clk _3008_/CLK clkbuf_4_7_0_clk/X VPWR VGND sg13cmos5l_buf_8
X_2607_ _2607_/Y _2607_/A _2609_/B VPWR VGND sg13cmos5l_xnor2_1
X_2538_ _2539_/B _3097_/D _3096_/D _3099_/D _3098_/D VPWR VGND sg13cmos5l_nor4_1
X_2469_ _2469_/Y _2975_/Q _2459_/A _2446_/B _2468_/Y VPWR VGND sg13cmos5l_a22oi_1
XFILLER_28_235 VPWR VGND sg13cmos5l_fill_1
XFILLER_43_216 VPWR VGND sg13cmos5l_decap_8
XFILLER_24_430 VPWR VGND sg13cmos5l_decap_8
XFILLER_40_912 VPWR VGND sg13cmos5l_decap_8
XFILLER_19_1014 VPWR VGND sg13cmos5l_decap_8
XFILLER_25_964 VPWR VGND sg13cmos5l_decap_8
XFILLER_11_102 VPWR VGND sg13cmos5l_decap_8
XFILLER_12_625 VPWR VGND sg13cmos5l_decap_8
XFILLER_40_989 VPWR VGND sg13cmos5l_decap_8
XFILLER_11_157 VPWR VGND sg13cmos5l_decap_8
XFILLER_3_301 VPWR VGND sg13cmos5l_decap_8
XFILLER_4_846 VPWR VGND sg13cmos5l_decap_8
XFILLER_26_1007 VPWR VGND sg13cmos5l_decap_8
Xfanout170 fanout170/X fanout171/X VPWR VGND sg13cmos5l_buf_1
XFILLER_19_213 VPWR VGND sg13cmos5l_decap_8
XFILLER_47_61 VPWR VGND sg13cmos5l_decap_8
XFILLER_47_566 VPWR VGND sg13cmos5l_decap_8
XFILLER_43_772 VPWR VGND sg13cmos5l_fill_2
XFILLER_16_986 VPWR VGND sg13cmos5l_decap_8
XFILLER_43_794 VPWR VGND sg13cmos5l_decap_8
XFILLER_43_783 VPWR VGND sg13cmos5l_fill_2
XFILLER_15_474 VPWR VGND sg13cmos5l_decap_8
XFILLER_31_934 VPWR VGND sg13cmos5l_decap_8
X_1840_ _1843_/C _2022_/A _1865_/A _2131_/B VPWR VGND sg13cmos5l_a21oi_1
XFILLER_30_444 VPWR VGND sg13cmos5l_fill_2
X_1771_ _2339_/B _1771_/A _1771_/B _2358_/B _1771_/D VPWR VGND sg13cmos5l_nand4_1
XFILLER_7_684 VPWR VGND sg13cmos5l_fill_2
XFILLER_7_673 VPWR VGND sg13cmos5l_decap_8
XFILLER_6_172 VPWR VGND sg13cmos5l_decap_8
X_2323_ _2323_/Y _2323_/A _2323_/B _2323_/C _2323_/D VPWR VGND sg13cmos5l_nor4_1
XFILLER_38_522 VPWR VGND sg13cmos5l_decap_8
X_2254_ _2254_/Y _2231_/A _2153_/B _2229_/B _1976_/Y _2280_/B VPWR VGND sg13cmos5l_a221oi_1
XFILLER_38_555 VPWR VGND sg13cmos5l_fill_1
XFILLER_38_533 VPWR VGND sg13cmos5l_fill_1
X_2185_ _2317_/B _2135_/A _2259_/B VPWR VGND sg13cmos5l_nand2b_1
XFILLER_38_588 VPWR VGND sg13cmos5l_decap_8
XFILLER_25_227 VPWR VGND sg13cmos5l_decap_8
XFILLER_18_290 VPWR VGND sg13cmos5l_decap_4
XFILLER_21_444 VPWR VGND sg13cmos5l_decap_8
XFILLER_22_967 VPWR VGND sg13cmos5l_decap_8
X_1969_ _2251_/C _2183_/A _2202_/C VPWR VGND sg13cmos5l_and2_1
XFILLER_49_1007 VPWR VGND sg13cmos5l_decap_8
XFILLER_0_304 VPWR VGND sg13cmos5l_decap_8
XFILLER_0_315 VPWR VGND sg13cmos5l_decap_8
XFILLER_1_849 VPWR VGND sg13cmos5l_decap_8
XFILLER_48_308 VPWR VGND sg13cmos5l_decap_8
XFILLER_29_522 VPWR VGND sg13cmos5l_decap_8
XFILLER_44_503 VPWR VGND sg13cmos5l_decap_8
XFILLER_16_205 VPWR VGND sg13cmos5l_fill_1
XFILLER_17_42 VPWR VGND sg13cmos5l_decap_8
XFILLER_29_599 VPWR VGND sg13cmos5l_decap_8
XFILLER_17_97 VPWR VGND sg13cmos5l_decap_4
XFILLER_25_750 VPWR VGND sg13cmos5l_decap_8
XFILLER_12_400 VPWR VGND sg13cmos5l_decap_8
XFILLER_24_260 VPWR VGND sg13cmos5l_decap_8
XFILLER_9_905 VPWR VGND sg13cmos5l_decap_8
XFILLER_13_967 VPWR VGND sg13cmos5l_decap_8
XFILLER_40_797 VPWR VGND sg13cmos5l_decap_8
XFILLER_12_477 VPWR VGND sg13cmos5l_decap_8
XFILLER_32_1011 VPWR VGND sg13cmos5l_decap_8
XFILLER_33_96 VPWR VGND sg13cmos5l_fill_2
XFILLER_4_643 VPWR VGND sg13cmos5l_decap_8
XFILLER_39_319 VPWR VGND sg13cmos5l_decap_8
XFILLER_48_886 VPWR VGND sg13cmos5l_decap_8
XFILLER_47_374 VPWR VGND sg13cmos5l_fill_2
XFILLER_47_352 VPWR VGND sg13cmos5l_fill_1
XFILLER_47_385 VPWR VGND sg13cmos5l_decap_8
XFILLER_16_761 VPWR VGND sg13cmos5l_decap_8
X_2941_ _2941_/Y _2923_/Y _2940_/Y hold403/X VPWR VGND sg13cmos5l_a21oi_1
XFILLER_22_208 VPWR VGND sg13cmos5l_decap_8
XFILLER_15_282 VPWR VGND sg13cmos5l_decap_8
XFILLER_31_731 VPWR VGND sg13cmos5l_decap_8
X_2872_ _2872_/Y _2872_/A _2880_/D VPWR VGND sg13cmos5l_xnor2_1
XFILLER_30_252 VPWR VGND sg13cmos5l_decap_8
X_1823_ _1823_/Y _1823_/A _1823_/B VPWR VGND sg13cmos5l_xnor2_1
XFILLER_30_296 VPWR VGND sg13cmos5l_decap_8
X_1754_ _1754_/X _2331_/A _1754_/B VPWR VGND sg13cmos5l_or2_1
Xhold426 hold426/X _3041_/Q VPWR VGND sg13cmos5l_dlygate4sd3_1
Xhold404 hold404/X _2941_/Y VPWR VGND sg13cmos5l_dlygate4sd3_1
Xhold415 _3087_/D _2966_/Y VPWR VGND sg13cmos5l_dlygate4sd3_1
Xhold437 hold437/X _3036_/Q VPWR VGND sg13cmos5l_dlygate4sd3_1
Xhold459 _2960_/B _2531_/A VPWR VGND sg13cmos5l_dlygate4sd3_1
Xhold448 hold448/X _3014_/Q VPWR VGND sg13cmos5l_dlygate4sd3_1
X_1685_ _1685_/Y _2362_/A _1679_/Y _1726_/A VPWR VGND sg13cmos5l_a21oi_1
X_2306_ _2306_/Y _2304_/X _2305_/Y _2032_/A VPWR VGND sg13cmos5l_a21oi_1
XFILLER_39_842 VPWR VGND sg13cmos5l_decap_8
X_2237_ _2237_/Y _2242_/A _2235_/Y _2236_/Y VPWR VGND sg13cmos5l_a21oi_1
XFILLER_38_363 VPWR VGND sg13cmos5l_decap_8
XFILLER_0_1020 VPWR VGND sg13cmos5l_decap_8
X_2168_ _2168_/X _2194_/A _2169_/B VPWR VGND sg13cmos5l_and2_1
XFILLER_26_547 VPWR VGND sg13cmos5l_decap_8
X_2099_ _2100_/B _2404_/A _2282_/A _2098_/Y _2158_/B VPWR VGND sg13cmos5l_a22oi_1
XFILLER_41_517 VPWR VGND sg13cmos5l_decap_8
XFILLER_21_230 VPWR VGND sg13cmos5l_decap_8
XFILLER_22_753 VPWR VGND sg13cmos5l_fill_1
XFILLER_10_937 VPWR VGND sg13cmos5l_decap_8
XFILLER_16_1028 VPWR VGND sg13cmos5l_fill_1
XFILLER_21_241 VPWR VGND sg13cmos5l_fill_1
XFILLER_21_263 VPWR VGND sg13cmos5l_decap_8
XFILLER_0_123 VPWR VGND sg13cmos5l_decap_8
XFILLER_1_646 VPWR VGND sg13cmos5l_decap_8
XFILLER_49_639 VPWR VGND sg13cmos5l_decap_8
XFILLER_28_63 VPWR VGND sg13cmos5l_decap_8
XFILLER_29_352 VPWR VGND sg13cmos5l_fill_1
XFILLER_45_856 VPWR VGND sg13cmos5l_decap_8
XFILLER_44_322 VPWR VGND sg13cmos5l_decap_8
XFILLER_44_399 VPWR VGND sg13cmos5l_decap_8
XFILLER_44_62 VPWR VGND sg13cmos5l_fill_2
XFILLER_9_702 VPWR VGND sg13cmos5l_decap_8
XFILLER_13_742 VPWR VGND sg13cmos5l_decap_8
XFILLER_40_583 VPWR VGND sg13cmos5l_decap_4
XFILLER_12_296 VPWR VGND sg13cmos5l_decap_8
XFILLER_9_779 VPWR VGND sg13cmos5l_decap_8
XFILLER_5_930 VPWR VGND sg13cmos5l_decap_8
XFILLER_4_440 VPWR VGND sg13cmos5l_fill_1
XFILLER_5_67 VPWR VGND sg13cmos5l_decap_8
XFILLER_4_473 VPWR VGND sg13cmos5l_fill_2
XFILLER_39_149 VPWR VGND sg13cmos5l_decap_8
XFILLER_10_4 VPWR VGND sg13cmos5l_decap_8
X_3071_ _3071_/Q _3072_/CLK _3071_/D fanout170/X VPWR VGND sg13cmos5l_dfrbpq_1
XFILLER_36_845 VPWR VGND sg13cmos5l_decap_8
X_2022_ _2023_/A _2022_/A _2183_/B _2266_/A _2041_/B VPWR VGND sg13cmos5l_nand4_1
XFILLER_39_1028 VPWR VGND sg13cmos5l_fill_1
XFILLER_39_1017 VPWR VGND sg13cmos5l_decap_8
XFILLER_35_377 VPWR VGND sg13cmos5l_decap_8
X_2924_ _2935_/A _3036_/Q _2951_/B VPWR VGND sg13cmos5l_xnor2_1
XFILLER_31_550 VPWR VGND sg13cmos5l_decap_4
X_2855_ _2914_/C _2855_/A _2902_/B VPWR VGND sg13cmos5l_nor2_1
X_1806_ _1814_/C _2869_/A _2944_/B VPWR VGND sg13cmos5l_xnor2_1
X_2786_ _2800_/B _3032_/Q _3048_/Q VPWR VGND sg13cmos5l_xnor2_1
Xhold201 _3097_/D _3096_/Q VPWR VGND sg13cmos5l_dlygate4sd3_1
X_1737_ _1737_/Y _1740_/A _1737_/B _1737_/C VPWR VGND sg13cmos5l_nor3_1
Xhold234 _2432_/A _3092_/Q VPWR VGND sg13cmos5l_dlygate4sd3_1
Xhold223 _3063_/D _2852_/Y VPWR VGND sg13cmos5l_dlygate4sd3_1
Xhold212 _2883_/A _3071_/Q VPWR VGND sg13cmos5l_dlygate4sd3_1
XFILLER_49_18 VPWR VGND sg13cmos5l_fill_2
Xhold256 _1525_/A _2987_/Q VPWR VGND sg13cmos5l_dlygate4sd3_1
Xhold278 _2486_/A _2978_/Q VPWR VGND sg13cmos5l_dlygate4sd3_1
X_1668_ _1738_/B _1633_/B _1644_/C _1698_/A VPWR VGND sg13cmos5l_o21ai_1
Xhold267 _2903_/A _3076_/Q VPWR VGND sg13cmos5l_dlygate4sd3_1
Xhold245 _2974_/D _2475_/Y VPWR VGND sg13cmos5l_dlygate4sd3_1
Xhold289 _2900_/A _3075_/Q VPWR VGND sg13cmos5l_dlygate4sd3_1
X_1599_ _1600_/B _1599_/A _1599_/B VPWR VGND sg13cmos5l_nor2_1
Xheichips26_daftASIC_182 uio_out[4] VPWR VGND sg13cmos5l_tielo
Xheichips26_daftASIC_193 uio_oe[5] VPWR VGND sg13cmos5l_tiehi
XFILLER_41_358 VPWR VGND sg13cmos5l_decap_8
XFILLER_41_325 VPWR VGND sg13cmos5l_decap_8
XFILLER_14_32 VPWR VGND sg13cmos5l_fill_1
XFILLER_14_54 VPWR VGND sg13cmos5l_decap_8
XFILLER_22_572 VPWR VGND sg13cmos5l_decap_8
XFILLER_5_237 VPWR VGND sg13cmos5l_decap_8
XFILLER_2_922 VPWR VGND sg13cmos5l_decap_8
XFILLER_30_97 VPWR VGND sg13cmos5l_decap_8
XFILLER_2_999 VPWR VGND sg13cmos5l_decap_8
XFILLER_39_84 VPWR VGND sg13cmos5l_decap_8
XFILLER_49_469 VPWR VGND sg13cmos5l_decap_8
Xclkbuf_4_3_0_clk clkbuf_4_3_0_clk/X clkbuf_0_clk/X VPWR VGND sg13cmos5l_buf_8
XFILLER_45_631 VPWR VGND sg13cmos5l_fill_2
XFILLER_17_300 VPWR VGND sg13cmos5l_fill_1
XFILLER_18_845 VPWR VGND sg13cmos5l_decap_8
XFILLER_45_653 VPWR VGND sg13cmos5l_decap_8
XFILLER_17_366 VPWR VGND sg13cmos5l_decap_8
XFILLER_17_377 VPWR VGND sg13cmos5l_fill_2
XFILLER_41_881 VPWR VGND sg13cmos5l_fill_1
X_2640_ _2640_/Y _2746_/A _2656_/A VPWR VGND sg13cmos5l_nand2_1
X_2571_ _2994_/D _2571_/A _2582_/S VPWR VGND sg13cmos5l_nor2b_1
X_1522_ _1522_/Y _2524_/A VPWR VGND sg13cmos5l_inv_1
XFILLER_45_1010 VPWR VGND sg13cmos5l_decap_8
XFILLER_4_281 VPWR VGND sg13cmos5l_fill_2
XFILLER_4_270 VPWR VGND sg13cmos5l_decap_8
X_3123_ _3123_/Q _3123_/CLK _3123_/D fanout151/X VPWR VGND sg13cmos5l_dfrbpq_1
X_3054_ _3054_/Q _3061_/CLK _3054_/D fanout175/X VPWR VGND sg13cmos5l_dfrbpq_1
XFILLER_36_653 VPWR VGND sg13cmos5l_decap_8
X_2005_ _2005_/Y _2005_/A _2005_/B _2005_/C VPWR VGND sg13cmos5l_nor3_1
X_2907_ _2914_/D _2907_/A _2907_/B VPWR VGND sg13cmos5l_and2_1
XFILLER_32_892 VPWR VGND sg13cmos5l_decap_8
XFILLER_13_1009 VPWR VGND sg13cmos5l_decap_8
X_2838_ _2838_/Y _2839_/A _2839_/B VPWR VGND sg13cmos5l_nor2_1
X_2769_ _3043_/D hold391/X _2754_/B _2768_/Y VPWR VGND sg13cmos5l_a21o_1
XFILLER_18_119 VPWR VGND sg13cmos5l_decap_4
XFILLER_27_620 VPWR VGND sg13cmos5l_fill_2
XFILLER_15_804 VPWR VGND sg13cmos5l_decap_8
XFILLER_26_152 VPWR VGND sg13cmos5l_fill_1
XFILLER_42_634 VPWR VGND sg13cmos5l_decap_8
XFILLER_41_155 VPWR VGND sg13cmos5l_fill_2
XFILLER_14_358 VPWR VGND sg13cmos5l_decap_8
XFILLER_25_75 VPWR VGND sg13cmos5l_decap_8
XFILLER_10_542 VPWR VGND sg13cmos5l_fill_1
XFILLER_6_513 VPWR VGND sg13cmos5l_fill_2
XFILLER_6_557 VPWR VGND sg13cmos5l_fill_1
XFILLER_37_9 VPWR VGND sg13cmos5l_decap_8
XFILLER_1_251 VPWR VGND sg13cmos5l_fill_1
XFILLER_49_200 VPWR VGND sg13cmos5l_decap_4
XFILLER_2_796 VPWR VGND sg13cmos5l_decap_8
XFILLER_2_24 VPWR VGND sg13cmos5l_decap_8
XFILLER_38_918 VPWR VGND sg13cmos5l_decap_8
XFILLER_46_995 VPWR VGND sg13cmos5l_decap_8
XFILLER_45_472 VPWR VGND sg13cmos5l_decap_8
XFILLER_18_664 VPWR VGND sg13cmos5l_decap_8
XFILLER_33_634 VPWR VGND sg13cmos5l_decap_8
XFILLER_33_678 VPWR VGND sg13cmos5l_decap_8
XFILLER_14_881 VPWR VGND sg13cmos5l_decap_8
XFILLER_20_328 VPWR VGND sg13cmos5l_decap_4
XFILLER_13_380 VPWR VGND sg13cmos5l_decap_8
X_2623_ _2623_/Y _2628_/B _2622_/Y _2621_/Y VPWR VGND sg13cmos5l_o21ai_1
X_2554_ _2993_/D _2554_/A VPWR VGND sg13cmos5l_inv_1
X_1505_ _2810_/B _3047_/Q VPWR VGND sg13cmos5l_inv_1
X_2485_ _2485_/Y _2980_/Q _2485_/A2 _2635_/B _2473_/Y VPWR VGND sg13cmos5l_a22oi_1
X_3106_ _3106_/Q clkload0/A _3106_/D fanout151/X VPWR VGND sg13cmos5l_dfrbpq_1
XFILLER_37_940 VPWR VGND sg13cmos5l_decap_8
X_3037_ _3037_/Q _3050_/CLK _3037_/D fanout170/X VPWR VGND sg13cmos5l_dfrbpq_1
XFILLER_36_450 VPWR VGND sg13cmos5l_decap_8
XFILLER_24_612 VPWR VGND sg13cmos5l_fill_1
XFILLER_12_818 VPWR VGND sg13cmos5l_decap_8
XFILLER_23_133 VPWR VGND sg13cmos5l_decap_8
XFILLER_3_505 VPWR VGND sg13cmos5l_decap_8
XFILLER_11_88 VPWR VGND sg13cmos5l_decap_8
XFILLER_47_704 VPWR VGND sg13cmos5l_fill_2
XFILLER_4_1007 VPWR VGND sg13cmos5l_decap_8
XFILLER_19_428 VPWR VGND sg13cmos5l_decap_8
XFILLER_46_236 VPWR VGND sg13cmos5l_decap_8
XFILLER_28_951 VPWR VGND sg13cmos5l_decap_8
XFILLER_42_431 VPWR VGND sg13cmos5l_decap_8
XFILLER_43_976 VPWR VGND sg13cmos5l_decap_8
XFILLER_15_667 VPWR VGND sg13cmos5l_decap_8
XFILLER_15_678 VPWR VGND sg13cmos5l_fill_1
XFILLER_35_1020 VPWR VGND sg13cmos5l_decap_8
XFILLER_14_166 VPWR VGND sg13cmos5l_decap_8
XFILLER_11_851 VPWR VGND sg13cmos5l_decap_8
XFILLER_7_811 VPWR VGND sg13cmos5l_decap_8
XFILLER_6_310 VPWR VGND sg13cmos5l_decap_8
XFILLER_10_350 VPWR VGND sg13cmos5l_fill_2
XFILLER_11_862 VPWR VGND sg13cmos5l_fill_1
XFILLER_11_873 VPWR VGND sg13cmos5l_decap_8
XFILLER_6_332 VPWR VGND sg13cmos5l_decap_8
XFILLER_10_394 VPWR VGND sg13cmos5l_decap_8
XFILLER_7_888 VPWR VGND sg13cmos5l_decap_8
XFILLER_6_376 VPWR VGND sg13cmos5l_decap_4
XFILLER_2_560 VPWR VGND sg13cmos5l_decap_8
XFILLER_2_593 VPWR VGND sg13cmos5l_decap_8
X_2270_ _2270_/Y _2270_/A _2270_/B _2270_/C VPWR VGND sg13cmos5l_nand3_1
XFILLER_19_951 VPWR VGND sg13cmos5l_decap_8
XFILLER_46_770 VPWR VGND sg13cmos5l_fill_1
XFILLER_34_910 VPWR VGND sg13cmos5l_decap_8
XFILLER_18_494 VPWR VGND sg13cmos5l_decap_8
XFILLER_33_453 VPWR VGND sg13cmos5l_decap_8
XFILLER_34_987 VPWR VGND sg13cmos5l_decap_8
XFILLER_20_114 VPWR VGND sg13cmos5l_decap_8
XFILLER_21_615 VPWR VGND sg13cmos5l_decap_8
X_1985_ _2212_/B _2196_/A _1985_/B VPWR VGND sg13cmos5l_nor2_1
X_2606_ _2606_/Y _2606_/A _2609_/B VPWR VGND sg13cmos5l_nor2b_1
X_2537_ _2537_/Y _3100_/D _3101_/D _3102_/D _2537_/D VPWR VGND sg13cmos5l_nand4_1
X_2468_ _2468_/Y _2673_/A _3023_/Q VPWR VGND sg13cmos5l_nor2_1
X_2399_ _2401_/D _3110_/Q _2414_/A _3109_/Q VPWR VGND sg13cmos5l_nand3b_1
XFILLER_25_943 VPWR VGND sg13cmos5l_decap_8
XFILLER_12_604 VPWR VGND sg13cmos5l_decap_8
XFILLER_40_968 VPWR VGND sg13cmos5l_decap_8
XFILLER_11_136 VPWR VGND sg13cmos5l_decap_8
XFILLER_7_129 VPWR VGND sg13cmos5l_decap_8
XFILLER_11_169 VPWR VGND sg13cmos5l_fill_2
XFILLER_22_32 VPWR VGND sg13cmos5l_decap_8
XFILLER_4_825 VPWR VGND sg13cmos5l_decap_8
Xfanout171 fanout171/X fanout178/X VPWR VGND sg13cmos5l_buf_1
XFILLER_47_501 VPWR VGND sg13cmos5l_fill_1
Xfanout160 fanout160/X fanout162/X VPWR VGND sg13cmos5l_buf_1
XFILLER_28_792 VPWR VGND sg13cmos5l_decap_4
XFILLER_43_751 VPWR VGND sg13cmos5l_decap_8
XFILLER_15_453 VPWR VGND sg13cmos5l_decap_8
XFILLER_16_965 VPWR VGND sg13cmos5l_decap_8
Xclkbuf_5_21__f_clk clkload5/A clkbuf_4_10_0_clk/X VPWR VGND sg13cmos5l_buf_8
XFILLER_31_913 VPWR VGND sg13cmos5l_decap_8
XFILLER_15_497 VPWR VGND sg13cmos5l_decap_8
XFILLER_8_34 VPWR VGND sg13cmos5l_decap_8
X_1770_ _1771_/D _2596_/A _1762_/B _1767_/Y _1768_/Y _1769_/Y VPWR VGND sg13cmos5l_a221oi_1
XFILLER_30_478 VPWR VGND sg13cmos5l_decap_8
XFILLER_30_489 VPWR VGND sg13cmos5l_fill_2
X_2322_ _2322_/Y _2322_/A _2322_/B _2322_/C _2322_/D VPWR VGND sg13cmos5l_nor4_1
XFILLER_2_390 VPWR VGND sg13cmos5l_decap_4
X_2253_ _2280_/B _2253_/A _2253_/B VPWR VGND sg13cmos5l_nor2_1
X_2184_ _2184_/Y _2181_/Y _2182_/Y _2226_/C _2194_/B VPWR VGND sg13cmos5l_a22oi_1
XFILLER_25_206 VPWR VGND sg13cmos5l_decap_8
XFILLER_26_707 VPWR VGND sg13cmos5l_decap_8
XFILLER_19_792 VPWR VGND sg13cmos5l_fill_1
XFILLER_40_209 VPWR VGND sg13cmos5l_decap_8
XFILLER_21_423 VPWR VGND sg13cmos5l_decap_8
XFILLER_22_946 VPWR VGND sg13cmos5l_decap_8
XFILLER_33_283 VPWR VGND sg13cmos5l_decap_8
XFILLER_21_478 VPWR VGND sg13cmos5l_decap_8
X_1968_ _2280_/A _1982_/A _2056_/B VPWR VGND sg13cmos5l_nor2_1
X_1899_ _1899_/Y _1899_/A VPWR VGND sg13cmos5l_inv_1
XFILLER_1_828 VPWR VGND sg13cmos5l_decap_8
XFILLER_17_21 VPWR VGND sg13cmos5l_decap_8
XFILLER_17_718 VPWR VGND sg13cmos5l_decap_4
XFILLER_17_729 VPWR VGND sg13cmos5l_decap_8
XFILLER_29_578 VPWR VGND sg13cmos5l_decap_8
XFILLER_16_239 VPWR VGND sg13cmos5l_decap_8
XFILLER_44_559 VPWR VGND sg13cmos5l_decap_8
XFILLER_13_946 VPWR VGND sg13cmos5l_decap_8
XFILLER_24_283 VPWR VGND sg13cmos5l_decap_8
XFILLER_40_776 VPWR VGND sg13cmos5l_decap_8
XFILLER_8_405 VPWR VGND sg13cmos5l_decap_8
XFILLER_12_456 VPWR VGND sg13cmos5l_decap_8
XFILLER_33_64 VPWR VGND sg13cmos5l_decap_8
XFILLER_8_449 VPWR VGND sg13cmos5l_decap_8
XFILLER_21_990 VPWR VGND sg13cmos5l_decap_8
XFILLER_4_622 VPWR VGND sg13cmos5l_decap_8
XFILLER_4_699 VPWR VGND sg13cmos5l_decap_8
XFILLER_3_165 VPWR VGND sg13cmos5l_fill_2
XFILLER_3_198 VPWR VGND sg13cmos5l_fill_1
XFILLER_0_894 VPWR VGND sg13cmos5l_decap_8
XFILLER_48_865 VPWR VGND sg13cmos5l_decap_8
XFILLER_35_515 VPWR VGND sg13cmos5l_decap_4
XFILLER_35_559 VPWR VGND sg13cmos5l_decap_8
X_2940_ _2940_/Y _2940_/A _2940_/B _2940_/C _2940_/D VPWR VGND sg13cmos5l_nor4_1
XFILLER_31_710 VPWR VGND sg13cmos5l_decap_8
X_2871_ _2871_/Y _2872_/A _2902_/B VPWR VGND sg13cmos5l_nand2_1
X_1822_ _3128_/D _2339_/B _1822_/B VPWR VGND sg13cmos5l_nor2_1
X_1753_ _1753_/Y _2605_/A _1749_/B _1754_/B _2331_/A _1750_/Y VPWR VGND sg13cmos5l_a221oi_1
Xhold416 _2544_/S _2990_/Q VPWR VGND sg13cmos5l_dlygate4sd3_1
Xhold427 _3041_/D _2753_/X VPWR VGND sg13cmos5l_dlygate4sd3_1
Xhold405 _3080_/D _2954_/Y VPWR VGND sg13cmos5l_dlygate4sd3_1
XFILLER_7_482 VPWR VGND sg13cmos5l_decap_8
X_1684_ _1684_/Y _1681_/A _1680_/Y _1683_/Y VPWR VGND sg13cmos5l_o21ai_1
Xhold438 _2503_/B _2996_/Q VPWR VGND sg13cmos5l_dlygate4sd3_1
Xhold449 _2600_/A _2595_/Y VPWR VGND sg13cmos5l_dlygate4sd3_1
XFILLER_39_810 VPWR VGND sg13cmos5l_decap_4
X_2305_ _2305_/Y _2224_/C _2296_/Y _2290_/C VPWR VGND sg13cmos5l_a21oi_1
XFILLER_38_331 VPWR VGND sg13cmos5l_decap_4
X_2236_ _2236_/Y _2272_/C _1974_/C _2131_/C VPWR VGND sg13cmos5l_o21ai_1
XFILLER_39_898 VPWR VGND sg13cmos5l_decap_8
X_2167_ _2171_/B _2139_/Y _2165_/X _2196_/C _2196_/B _2272_/C VPWR VGND sg13cmos5l_a221oi_1
X_2098_ _2098_/Y _2098_/A _2098_/B VPWR VGND sg13cmos5l_nor2_1
XFILLER_34_570 VPWR VGND sg13cmos5l_decap_4
XFILLER_16_1007 VPWR VGND sg13cmos5l_decap_8
XFILLER_22_732 VPWR VGND sg13cmos5l_decap_8
XFILLER_34_581 VPWR VGND sg13cmos5l_decap_8
XFILLER_10_916 VPWR VGND sg13cmos5l_decap_8
XFILLER_22_765 VPWR VGND sg13cmos5l_decap_8
XFILLER_0_102 VPWR VGND sg13cmos5l_decap_8
XFILLER_1_625 VPWR VGND sg13cmos5l_decap_8
XFILLER_49_618 VPWR VGND sg13cmos5l_decap_8
XFILLER_0_179 VPWR VGND sg13cmos5l_decap_8
XFILLER_45_813 VPWR VGND sg13cmos5l_decap_8
XFILLER_28_42 VPWR VGND sg13cmos5l_decap_8
XFILLER_28_53 VPWR VGND sg13cmos5l_fill_1
XFILLER_29_364 VPWR VGND sg13cmos5l_decap_8
XFILLER_44_301 VPWR VGND sg13cmos5l_fill_1
XFILLER_44_378 VPWR VGND sg13cmos5l_decap_8
XFILLER_44_41 VPWR VGND sg13cmos5l_decap_8
XFILLER_32_507 VPWR VGND sg13cmos5l_decap_8
XFILLER_12_220 VPWR VGND sg13cmos5l_fill_1
XFILLER_13_721 VPWR VGND sg13cmos5l_decap_8
XFILLER_8_202 VPWR VGND sg13cmos5l_decap_8
XFILLER_9_758 VPWR VGND sg13cmos5l_decap_8
XFILLER_12_264 VPWR VGND sg13cmos5l_fill_2
XFILLER_5_46 VPWR VGND sg13cmos5l_decap_8
XFILLER_5_986 VPWR VGND sg13cmos5l_decap_8
XFILLER_39_128 VPWR VGND sg13cmos5l_decap_8
XFILLER_0_691 VPWR VGND sg13cmos5l_decap_8
X_3070_ _3070_/Q _3072_/CLK _3070_/D fanout170/X VPWR VGND sg13cmos5l_dfrbpq_1
X_2021_ _2086_/B _2205_/A _2021_/B VPWR VGND sg13cmos5l_nand2_1
XFILLER_47_161 VPWR VGND sg13cmos5l_fill_1
XFILLER_36_824 VPWR VGND sg13cmos5l_decap_8
XFILLER_47_183 VPWR VGND sg13cmos5l_decap_8
XFILLER_35_334 VPWR VGND sg13cmos5l_decap_8
XFILLER_44_890 VPWR VGND sg13cmos5l_decap_8
XFILLER_16_581 VPWR VGND sg13cmos5l_fill_1
X_2923_ _2923_/Y _2917_/Y _2918_/X _2921_/X _2922_/Y _2920_/Y VPWR VGND sg13cmos5l_a221oi_1
X_2854_ _2911_/A _2854_/A _2854_/B VPWR VGND sg13cmos5l_or2_1
X_2785_ _2800_/A _3045_/Q _3061_/Q VPWR VGND sg13cmos5l_xnor2_1
X_1805_ _1805_/Y _3072_/Q _1805_/B VPWR VGND sg13cmos5l_xnor2_1
Xhold202 _3098_/D _3097_/Q VPWR VGND sg13cmos5l_dlygate4sd3_1
X_1736_ _1737_/C _1738_/A _1736_/B _1736_/C VPWR VGND sg13cmos5l_nor3_1
Xhold224 _2551_/C _2992_/Q VPWR VGND sg13cmos5l_dlygate4sd3_1
Xhold235 _2426_/C _2641_/D VPWR VGND sg13cmos5l_dlygate4sd3_1
Xhold213 _3071_/D _2886_/Y VPWR VGND sg13cmos5l_dlygate4sd3_1
Xhold246 _2524_/A _2984_/Q VPWR VGND sg13cmos5l_dlygate4sd3_1
Xhold257 _2987_/D _2532_/Y VPWR VGND sg13cmos5l_dlygate4sd3_1
X_1667_ _1733_/B _1726_/D _1646_/D _1726_/C VPWR VGND sg13cmos5l_a21oi_1
Xhold268 _3076_/D _2905_/Y VPWR VGND sg13cmos5l_dlygate4sd3_1
X_1598_ _1745_/A _1598_/A _1655_/C _1598_/C VPWR VGND sg13cmos5l_nand3_1
Xhold279 hold279/X _2486_/Y VPWR VGND sg13cmos5l_dlygate4sd3_1
XFILLER_39_662 VPWR VGND sg13cmos5l_decap_8
Xheichips26_daftASIC_183 uio_out[5] VPWR VGND sg13cmos5l_tielo
Xheichips26_daftASIC_194 uio_oe[6] VPWR VGND sg13cmos5l_tiehi
XFILLER_39_684 VPWR VGND sg13cmos5l_fill_1
X_2219_ _2222_/B _2204_/A _2168_/X _2194_/B VPWR VGND sg13cmos5l_o21ai_1
XFILLER_26_312 VPWR VGND sg13cmos5l_fill_2
XFILLER_27_824 VPWR VGND sg13cmos5l_fill_2
XFILLER_26_356 VPWR VGND sg13cmos5l_decap_4
XFILLER_42_827 VPWR VGND sg13cmos5l_fill_1
XFILLER_42_816 VPWR VGND sg13cmos5l_decap_8
XFILLER_41_348 VPWR VGND sg13cmos5l_decap_4
XFILLER_14_11 VPWR VGND sg13cmos5l_decap_8
XFILLER_10_724 VPWR VGND sg13cmos5l_fill_2
XFILLER_14_88 VPWR VGND sg13cmos5l_decap_8
XFILLER_14_99 VPWR VGND sg13cmos5l_fill_1
XFILLER_6_739 VPWR VGND sg13cmos5l_decap_8
XFILLER_2_901 VPWR VGND sg13cmos5l_decap_8
XFILLER_30_76 VPWR VGND sg13cmos5l_decap_8
XFILLER_39_41 VPWR VGND sg13cmos5l_fill_2
XFILLER_2_978 VPWR VGND sg13cmos5l_decap_8
XFILLER_49_448 VPWR VGND sg13cmos5l_decap_8
XFILLER_39_63 VPWR VGND sg13cmos5l_decap_8
XFILLER_17_312 VPWR VGND sg13cmos5l_decap_8
XFILLER_18_824 VPWR VGND sg13cmos5l_decap_8
XFILLER_45_643 VPWR VGND sg13cmos5l_fill_2
XFILLER_17_389 VPWR VGND sg13cmos5l_decap_8
XFILLER_33_816 VPWR VGND sg13cmos5l_fill_2
XFILLER_32_315 VPWR VGND sg13cmos5l_decap_8
XFILLER_13_562 VPWR VGND sg13cmos5l_decap_8
XFILLER_13_573 VPWR VGND sg13cmos5l_fill_2
XFILLER_9_566 VPWR VGND sg13cmos5l_decap_8
X_2570_ _2570_/Y _2570_/A _2570_/B VPWR VGND sg13cmos5l_nand2_1
X_1521_ _1521_/Y _1521_/A VPWR VGND sg13cmos5l_inv_1
XFILLER_5_783 VPWR VGND sg13cmos5l_decap_8
X_3122_ _3122_/Q _3122_/CLK _3122_/D fanout151/X VPWR VGND sg13cmos5l_dfrbpq_1
XFILLER_49_993 VPWR VGND sg13cmos5l_decap_8
X_3053_ _3053_/Q _3061_/CLK _3053_/D fanout173/X VPWR VGND sg13cmos5l_dfrbpq_1
X_2004_ _2005_/C _2056_/B _2002_/Y _1982_/A VPWR VGND sg13cmos5l_a21oi_1
XFILLER_35_142 VPWR VGND sg13cmos5l_decap_8
XFILLER_24_805 VPWR VGND sg13cmos5l_fill_2
XFILLER_35_197 VPWR VGND sg13cmos5l_decap_4
XFILLER_35_186 VPWR VGND sg13cmos5l_fill_2
X_2906_ _2906_/Y _2907_/A _2911_/A VPWR VGND sg13cmos5l_nand2_1
X_2837_ _2837_/Y _2843_/A _2837_/B _2839_/B VPWR VGND sg13cmos5l_nor3_1
X_2768_ _2768_/Y _2763_/Y _2766_/Y _2767_/Y VPWR VGND sg13cmos5l_a21oi_1
X_2699_ _2699_/X _3035_/Q _2699_/B VPWR VGND sg13cmos5l_xor2_1
XFILLER_2_219 VPWR VGND sg13cmos5l_decap_8
X_1719_ _1719_/Y _1613_/C _1739_/B _1711_/Y VPWR VGND sg13cmos5l_o21ai_1
XFILLER_39_492 VPWR VGND sg13cmos5l_decap_8
XFILLER_42_613 VPWR VGND sg13cmos5l_decap_8
Xclkbuf_5_2__f_clk _3123_/CLK clkbuf_4_1_0_clk/X VPWR VGND sg13cmos5l_buf_8
XFILLER_14_337 VPWR VGND sg13cmos5l_decap_8
XFILLER_25_54 VPWR VGND sg13cmos5l_decap_8
XFILLER_42_657 VPWR VGND sg13cmos5l_fill_1
XFILLER_22_392 VPWR VGND sg13cmos5l_decap_8
XFILLER_41_42 VPWR VGND sg13cmos5l_decap_8
XFILLER_10_554 VPWR VGND sg13cmos5l_decap_8
XFILLER_29_1028 VPWR VGND sg13cmos5l_fill_1
XFILLER_2_775 VPWR VGND sg13cmos5l_decap_8
XFILLER_1_296 VPWR VGND sg13cmos5l_fill_2
XFILLER_49_289 VPWR VGND sg13cmos5l_decap_8
XFILLER_18_643 VPWR VGND sg13cmos5l_decap_8
XFILLER_46_974 VPWR VGND sg13cmos5l_decap_8
XFILLER_17_175 VPWR VGND sg13cmos5l_fill_2
XFILLER_14_871 VPWR VGND sg13cmos5l_decap_4
XFILLER_32_167 VPWR VGND sg13cmos5l_fill_1
XFILLER_9_363 VPWR VGND sg13cmos5l_decap_8
XFILLER_9_385 VPWR VGND sg13cmos5l_decap_8
XFILLER_12_1010 VPWR VGND sg13cmos5l_decap_8
X_2622_ _2622_/Y _2446_/B _2630_/B _3024_/Q VPWR VGND sg13cmos5l_a21oi_1
X_2553_ _2553_/Y _2552_/A _2568_/A _2592_/S _2552_/Y VPWR VGND sg13cmos5l_a22oi_1
X_1504_ _2653_/A _1504_/A VPWR VGND sg13cmos5l_inv_1
X_2484_ _2484_/Y _2486_/B _2482_/Y hold312/X VPWR VGND sg13cmos5l_a21oi_1
X_3105_ _3105_/Q clkload0/A _3105_/D fanout151/X VPWR VGND sg13cmos5l_dfrbpq_1
XFILLER_49_790 VPWR VGND sg13cmos5l_decap_8
X_3036_ _3036_/Q _3036_/CLK _3036_/D fanout170/X VPWR VGND sg13cmos5l_dfrbpq_1
XFILLER_37_996 VPWR VGND sg13cmos5l_decap_8
XFILLER_36_440 VPWR VGND sg13cmos5l_decap_4
XFILLER_24_635 VPWR VGND sg13cmos5l_decap_8
XFILLER_11_318 VPWR VGND sg13cmos5l_decap_8
XFILLER_20_863 VPWR VGND sg13cmos5l_fill_2
Xclkbuf_4_2_0_clk clkbuf_4_2_0_clk/X clkbuf_0_clk/X VPWR VGND sg13cmos5l_buf_8
XFILLER_11_23 VPWR VGND sg13cmos5l_decap_8
XFILLER_11_78 VPWR VGND sg13cmos5l_decap_4
XFILLER_19_407 VPWR VGND sg13cmos5l_decap_8
XFILLER_28_930 VPWR VGND sg13cmos5l_decap_8
XFILLER_36_64 VPWR VGND sg13cmos5l_fill_1
XFILLER_42_410 VPWR VGND sg13cmos5l_fill_1
XFILLER_14_112 VPWR VGND sg13cmos5l_fill_2
XFILLER_15_613 VPWR VGND sg13cmos5l_decap_8
XFILLER_27_495 VPWR VGND sg13cmos5l_decap_8
XFILLER_43_955 VPWR VGND sg13cmos5l_decap_8
XFILLER_30_605 VPWR VGND sg13cmos5l_decap_8
XFILLER_42_487 VPWR VGND sg13cmos5l_decap_8
XFILLER_30_627 VPWR VGND sg13cmos5l_decap_8
XFILLER_7_867 VPWR VGND sg13cmos5l_decap_8
XFILLER_10_384 VPWR VGND sg13cmos5l_decap_4
XFILLER_35_7 VPWR VGND sg13cmos5l_decap_8
XFILLER_37_226 VPWR VGND sg13cmos5l_decap_8
XFILLER_19_930 VPWR VGND sg13cmos5l_decap_8
XFILLER_18_473 VPWR VGND sg13cmos5l_decap_4
XFILLER_34_966 VPWR VGND sg13cmos5l_decap_8
X_1984_ _1984_/Y _1895_/A _1983_/Y _1982_/Y VPWR VGND sg13cmos5l_a21oi_1
X_2605_ _2609_/B _2605_/A _2605_/B _2605_/C _2605_/D VPWR VGND sg13cmos5l_nand4_1
X_2536_ _2536_/Y _2499_/C _2963_/C _2535_/Y VPWR VGND sg13cmos5l_o21ai_1
X_2467_ _2467_/X hold364/X _2964_/A1 _2490_/B VPWR VGND sg13cmos5l_mux2_1
X_2398_ _2398_/Y _2398_/A _2398_/B VPWR VGND sg13cmos5l_nor2_1
XFILLER_28_215 VPWR VGND sg13cmos5l_decap_8
X_3019_ _3019_/Q _3135_/CLK _3019_/D fanout167/X VPWR VGND sg13cmos5l_dfrbpq_1
XFILLER_25_922 VPWR VGND sg13cmos5l_decap_8
XFILLER_36_292 VPWR VGND sg13cmos5l_decap_8
XFILLER_24_476 VPWR VGND sg13cmos5l_decap_8
XFILLER_25_999 VPWR VGND sg13cmos5l_decap_8
XFILLER_40_947 VPWR VGND sg13cmos5l_decap_8
XFILLER_8_609 VPWR VGND sg13cmos5l_decap_8
XFILLER_7_108 VPWR VGND sg13cmos5l_decap_8
XFILLER_22_11 VPWR VGND sg13cmos5l_decap_8
XFILLER_4_804 VPWR VGND sg13cmos5l_decap_8
XFILLER_22_99 VPWR VGND sg13cmos5l_decap_4
XFILLER_3_369 VPWR VGND sg13cmos5l_decap_8
XFILLER_3_358 VPWR VGND sg13cmos5l_fill_1
XFILLER_3_347 VPWR VGND sg13cmos5l_decap_8
Xfanout161 fanout161/X fanout162/X VPWR VGND sg13cmos5l_buf_1
Xfanout172 fanout172/X fanout173/X VPWR VGND sg13cmos5l_buf_1
Xfanout150 fanout150/X fanout151/X VPWR VGND sg13cmos5l_buf_1
XFILLER_47_535 VPWR VGND sg13cmos5l_decap_4
XFILLER_35_708 VPWR VGND sg13cmos5l_fill_1
XFILLER_19_248 VPWR VGND sg13cmos5l_decap_8
XFILLER_16_944 VPWR VGND sg13cmos5l_decap_8
XFILLER_15_432 VPWR VGND sg13cmos5l_decap_8
XFILLER_27_292 VPWR VGND sg13cmos5l_decap_8
XFILLER_8_13 VPWR VGND sg13cmos5l_decap_8
XFILLER_30_424 VPWR VGND sg13cmos5l_fill_1
XFILLER_31_969 VPWR VGND sg13cmos5l_decap_8
XFILLER_30_457 VPWR VGND sg13cmos5l_decap_8
XFILLER_8_79 VPWR VGND sg13cmos5l_decap_8
XFILLER_11_671 VPWR VGND sg13cmos5l_decap_8
XFILLER_7_653 VPWR VGND sg13cmos5l_fill_1
XFILLER_10_181 VPWR VGND sg13cmos5l_decap_8
XFILLER_6_163 VPWR VGND sg13cmos5l_decap_4
X_2321_ _2323_/D _2321_/A _2320_/Y VPWR VGND sg13cmos5l_nor2b_1
X_2252_ _2253_/B _1839_/X _1974_/C _2286_/B VPWR VGND sg13cmos5l_a21oi_1
XFILLER_38_502 VPWR VGND sg13cmos5l_fill_1
XFILLER_38_546 VPWR VGND sg13cmos5l_decap_8
X_2183_ _2226_/C _2183_/A _2183_/B _2183_/C VPWR VGND sg13cmos5l_nor3_1
XFILLER_46_590 VPWR VGND sg13cmos5l_decap_4
XFILLER_21_402 VPWR VGND sg13cmos5l_decap_8
XFILLER_22_925 VPWR VGND sg13cmos5l_decap_8
XFILLER_33_262 VPWR VGND sg13cmos5l_decap_8
XFILLER_34_763 VPWR VGND sg13cmos5l_decap_4
XFILLER_34_785 VPWR VGND sg13cmos5l_decap_8
XFILLER_34_796 VPWR VGND sg13cmos5l_fill_1
X_1967_ _2056_/B _2186_/C _1908_/C _2240_/A VPWR VGND sg13cmos5l_o21ai_1
X_1898_ _1899_/A _2244_/B _2308_/D _2244_/C VPWR VGND sg13cmos5l_o21ai_1
XFILLER_1_807 VPWR VGND sg13cmos5l_decap_8
X_2519_ _2519_/Y _2510_/C _2963_/C _2518_/Y VPWR VGND sg13cmos5l_o21ai_1
XFILLER_25_1020 VPWR VGND sg13cmos5l_decap_8
XFILLER_29_557 VPWR VGND sg13cmos5l_decap_8
XFILLER_29_568 VPWR VGND sg13cmos5l_fill_2
XFILLER_44_538 VPWR VGND sg13cmos5l_decap_8
XFILLER_16_218 VPWR VGND sg13cmos5l_decap_8
XFILLER_37_590 VPWR VGND sg13cmos5l_decap_8
XFILLER_13_925 VPWR VGND sg13cmos5l_decap_8
XFILLER_40_755 VPWR VGND sg13cmos5l_decap_8
XFILLER_12_435 VPWR VGND sg13cmos5l_decap_8
XFILLER_33_43 VPWR VGND sg13cmos5l_decap_8
XFILLER_4_678 VPWR VGND sg13cmos5l_decap_8
XFILLER_0_873 VPWR VGND sg13cmos5l_decap_8
XFILLER_48_844 VPWR VGND sg13cmos5l_decap_8
XFILLER_16_741 VPWR VGND sg13cmos5l_fill_2
XFILLER_15_262 VPWR VGND sg13cmos5l_decap_4
XFILLER_16_785 VPWR VGND sg13cmos5l_fill_1
XFILLER_31_700 VPWR VGND sg13cmos5l_fill_1
X_2870_ _2870_/Y _2886_/A1 _2869_/Y _2867_/Y VPWR VGND sg13cmos5l_o21ai_1
X_1821_ _1822_/B _1821_/A _1821_/B VPWR VGND sg13cmos5l_xnor2_1
XFILLER_30_232 VPWR VGND sg13cmos5l_fill_2
XFILLER_8_984 VPWR VGND sg13cmos5l_decap_8
X_1752_ _1754_/B _3135_/Q _1752_/B VPWR VGND sg13cmos5l_xnor2_1
Xhold406 _2771_/A _3044_/Q VPWR VGND sg13cmos5l_dlygate4sd3_1
Xhold417 _2649_/A _3030_/Q VPWR VGND sg13cmos5l_dlygate4sd3_1
X_1683_ _1683_/Y _1681_/Y _1683_/B VPWR VGND sg13cmos5l_nand2b_1
Xhold439 _2508_/A _2516_/A VPWR VGND sg13cmos5l_dlygate4sd3_1
Xhold428 _1503_/A _3046_/Q VPWR VGND sg13cmos5l_dlygate4sd3_1
X_2304_ _2304_/X _2300_/Y _2303_/Y _2224_/C VPWR VGND sg13cmos5l_a21o_1
X_2235_ _2235_/Y _2251_/C _2235_/B VPWR VGND sg13cmos5l_nand2b_1
XFILLER_39_877 VPWR VGND sg13cmos5l_decap_8
X_2166_ _2196_/C _2166_/A _2311_/A _2194_/A VPWR VGND sg13cmos5l_nand3_1
XFILLER_38_398 VPWR VGND sg13cmos5l_decap_8
X_2097_ _2098_/B _2113_/A _2097_/B VPWR VGND sg13cmos5l_nor2_1
X_2999_ _2999_/Q clkload3/A _2999_/D fanout162/X VPWR VGND sg13cmos5l_dfrbpq_1
XFILLER_21_298 VPWR VGND sg13cmos5l_decap_8
XFILLER_1_604 VPWR VGND sg13cmos5l_decap_8
XFILLER_0_158 VPWR VGND sg13cmos5l_decap_8
XFILLER_17_527 VPWR VGND sg13cmos5l_decap_8
XFILLER_17_538 VPWR VGND sg13cmos5l_fill_2
XFILLER_28_98 VPWR VGND sg13cmos5l_decap_8
XFILLER_44_357 VPWR VGND sg13cmos5l_decap_8
XFILLER_17_549 VPWR VGND sg13cmos5l_fill_2
XFILLER_44_64 VPWR VGND sg13cmos5l_fill_1
XFILLER_12_210 VPWR VGND sg13cmos5l_fill_1
XFILLER_40_541 VPWR VGND sg13cmos5l_decap_8
XFILLER_12_232 VPWR VGND sg13cmos5l_fill_2
XFILLER_12_243 VPWR VGND sg13cmos5l_decap_8
XFILLER_13_777 VPWR VGND sg13cmos5l_fill_2
XFILLER_9_737 VPWR VGND sg13cmos5l_decap_8
XFILLER_12_276 VPWR VGND sg13cmos5l_fill_1
XFILLER_13_799 VPWR VGND sg13cmos5l_fill_2
XFILLER_5_965 VPWR VGND sg13cmos5l_decap_8
XFILLER_39_107 VPWR VGND sg13cmos5l_decap_8
XFILLER_0_670 VPWR VGND sg13cmos5l_decap_8
XFILLER_36_803 VPWR VGND sg13cmos5l_decap_8
X_2020_ _2286_/A _2205_/A _2294_/B _2240_/B VPWR VGND sg13cmos5l_nor3_1
XFILLER_35_313 VPWR VGND sg13cmos5l_decap_8
XFILLER_23_519 VPWR VGND sg13cmos5l_fill_2
X_2922_ _2922_/Y _3030_/Q _3031_/Q _2922_/C VPWR VGND sg13cmos5l_nand3_1
X_2853_ _2854_/B _3087_/Q _1815_/B _1500_/A VPWR VGND sg13cmos5l_a21oi_1
XFILLER_31_585 VPWR VGND sg13cmos5l_decap_8
X_2784_ _2801_/A _3039_/Q _3055_/Q VPWR VGND sg13cmos5l_xor2_1
X_1804_ _1812_/C _3070_/Q _2674_/A VPWR VGND sg13cmos5l_xor2_1
XFILLER_8_781 VPWR VGND sg13cmos5l_decap_8
X_1735_ _1736_/C _1610_/B _1697_/D _1698_/A VPWR VGND sg13cmos5l_a21oi_1
Xhold225 _2992_/D _2550_/X VPWR VGND sg13cmos5l_dlygate4sd3_1
Xhold203 _3103_/D _3013_/Q VPWR VGND sg13cmos5l_dlygate4sd3_1
Xhold214 _2867_/A _3067_/Q VPWR VGND sg13cmos5l_dlygate4sd3_1
Xhold247 _2984_/D _2525_/Y VPWR VGND sg13cmos5l_dlygate4sd3_1
Xhold269 _2818_/B _3051_/Q VPWR VGND sg13cmos5l_dlygate4sd3_1
Xhold258 _2381_/A _3117_/Q VPWR VGND sg13cmos5l_dlygate4sd3_1
X_1666_ _1666_/Y _1720_/A _1736_/B _1733_/A VPWR VGND sg13cmos5l_o21ai_1
Xhold236 _2438_/A _2433_/A VPWR VGND sg13cmos5l_dlygate4sd3_1
X_1597_ _1599_/B _1655_/C _1598_/C _1598_/A VPWR VGND sg13cmos5l_a21oi_1
Xheichips26_daftASIC_184 uio_out[6] VPWR VGND sg13cmos5l_tielo
XFILLER_22_1023 VPWR VGND sg13cmos5l_decap_4
Xheichips26_daftASIC_195 uio_oe[7] VPWR VGND sg13cmos5l_tiehi
XFILLER_27_803 VPWR VGND sg13cmos5l_fill_2
X_2218_ _2218_/Y _2222_/A _2218_/B _2218_/C VPWR VGND sg13cmos5l_nand3_1
XFILLER_27_836 VPWR VGND sg13cmos5l_decap_8
X_2149_ _2149_/Y _2153_/A _2149_/B VPWR VGND sg13cmos5l_nor2_1
XFILLER_26_346 VPWR VGND sg13cmos5l_decap_4
XFILLER_27_847 VPWR VGND sg13cmos5l_fill_2
XFILLER_42_839 VPWR VGND sg13cmos5l_decap_8
XFILLER_14_508 VPWR VGND sg13cmos5l_decap_4
XFILLER_35_880 VPWR VGND sg13cmos5l_decap_8
XFILLER_6_718 VPWR VGND sg13cmos5l_decap_8
XFILLER_10_747 VPWR VGND sg13cmos5l_fill_1
XFILLER_30_11 VPWR VGND sg13cmos5l_decap_8
XFILLER_2_957 VPWR VGND sg13cmos5l_decap_8
XFILLER_49_427 VPWR VGND sg13cmos5l_decap_8
XFILLER_39_53 VPWR VGND sg13cmos5l_fill_1
XFILLER_7_1028 VPWR VGND sg13cmos5l_fill_1
XFILLER_18_803 VPWR VGND sg13cmos5l_decap_8
XFILLER_45_611 VPWR VGND sg13cmos5l_fill_2
XFILLER_45_633 VPWR VGND sg13cmos5l_fill_1
XFILLER_17_335 VPWR VGND sg13cmos5l_decap_8
XFILLER_29_195 VPWR VGND sg13cmos5l_fill_2
XFILLER_44_143 VPWR VGND sg13cmos5l_fill_1
XFILLER_44_132 VPWR VGND sg13cmos5l_decap_8
XFILLER_26_880 VPWR VGND sg13cmos5l_decap_8
XFILLER_41_872 VPWR VGND sg13cmos5l_decap_8
XFILLER_9_545 VPWR VGND sg13cmos5l_decap_8
XFILLER_5_762 VPWR VGND sg13cmos5l_decap_8
X_1520_ _1520_/Y _1520_/A VPWR VGND sg13cmos5l_inv_1
XFILLER_4_294 VPWR VGND sg13cmos5l_decap_8
X_3121_ _3121_/Q _3123_/CLK _3121_/D fanout150/X VPWR VGND sg13cmos5l_dfrbpq_1
XFILLER_49_972 VPWR VGND sg13cmos5l_decap_8
X_3052_ _3052_/Q _3061_/CLK _3052_/D fanout173/X VPWR VGND sg13cmos5l_dfrbpq_1
XFILLER_36_611 VPWR VGND sg13cmos5l_decap_8
XFILLER_36_644 VPWR VGND sg13cmos5l_decap_4
X_2003_ _2005_/B _2194_/A _2003_/B _2003_/C VPWR VGND sg13cmos5l_nor3_1
XFILLER_24_839 VPWR VGND sg13cmos5l_decap_8
X_2905_ _2905_/Y _2907_/B _2904_/Y _2902_/Y VPWR VGND sg13cmos5l_o21ai_1
X_2836_ _2839_/B _2836_/A _2836_/B VPWR VGND sg13cmos5l_and2_1
X_2767_ _2767_/Y _2763_/Y _2766_/Y _2645_/Y VPWR VGND sg13cmos5l_o21ai_1
X_2698_ _2709_/A _3035_/Q _2699_/B VPWR VGND sg13cmos5l_nor2_1
X_1718_ _1725_/A _1717_/Y _1718_/B _1718_/C VPWR VGND sg13cmos5l_nand3b_1
X_1649_ _1818_/B _1696_/A _1705_/C VPWR VGND sg13cmos5l_nor2_1
XFILLER_47_909 VPWR VGND sg13cmos5l_decap_8
XFILLER_39_471 VPWR VGND sg13cmos5l_decap_8
XFILLER_27_633 VPWR VGND sg13cmos5l_decap_8
XFILLER_27_644 VPWR VGND sg13cmos5l_fill_1
XFILLER_25_11 VPWR VGND sg13cmos5l_decap_8
XFILLER_26_132 VPWR VGND sg13cmos5l_decap_4
XFILLER_14_316 VPWR VGND sg13cmos5l_decap_8
XFILLER_15_839 VPWR VGND sg13cmos5l_decap_8
XFILLER_25_33 VPWR VGND sg13cmos5l_decap_8
XFILLER_26_198 VPWR VGND sg13cmos5l_decap_8
XFILLER_41_124 VPWR VGND sg13cmos5l_decap_4
XFILLER_23_872 VPWR VGND sg13cmos5l_decap_8
XFILLER_41_21 VPWR VGND sg13cmos5l_decap_8
XFILLER_10_533 VPWR VGND sg13cmos5l_decap_8
XFILLER_6_515 VPWR VGND sg13cmos5l_fill_1
XFILLER_6_548 VPWR VGND sg13cmos5l_decap_8
XFILLER_29_1007 VPWR VGND sg13cmos5l_decap_8
XFILLER_2_754 VPWR VGND sg13cmos5l_decap_8
XFILLER_1_264 VPWR VGND sg13cmos5l_fill_1
XFILLER_2_59 VPWR VGND sg13cmos5l_decap_4
XFILLER_49_268 VPWR VGND sg13cmos5l_decap_8
XFILLER_46_953 VPWR VGND sg13cmos5l_decap_8
XFILLER_18_622 VPWR VGND sg13cmos5l_decap_8
XFILLER_17_154 VPWR VGND sg13cmos5l_decap_8
XFILLER_41_691 VPWR VGND sg13cmos5l_fill_1
X_2621_ _2621_/Y _2621_/A _2628_/B VPWR VGND sg13cmos5l_nand2_1
X_2552_ _2552_/Y _2552_/A _2552_/B VPWR VGND sg13cmos5l_xnor2_1
X_1503_ _2810_/A _1503_/A VPWR VGND sg13cmos5l_inv_1
X_2483_ _2483_/Y _2483_/A _2486_/B VPWR VGND sg13cmos5l_nor2_1
XFILLER_29_909 VPWR VGND sg13cmos5l_decap_8
X_3104_ _3104_/Q clkload0/A _3104_/D fanout151/X VPWR VGND sg13cmos5l_dfrbpq_1
X_3035_ _3035_/Q _3036_/CLK _3035_/D fanout171/X VPWR VGND sg13cmos5l_dfrbpq_1
XFILLER_37_975 VPWR VGND sg13cmos5l_decap_8
XFILLER_36_430 VPWR VGND sg13cmos5l_fill_1
XFILLER_36_496 VPWR VGND sg13cmos5l_decap_8
XFILLER_20_842 VPWR VGND sg13cmos5l_fill_1
X_2819_ _2819_/Y _2822_/A _2819_/B _2821_/B VPWR VGND sg13cmos5l_nor3_1
XFILLER_3_518 VPWR VGND sg13cmos5l_decap_8
XFILLER_11_57 VPWR VGND sg13cmos5l_decap_8
XFILLER_36_43 VPWR VGND sg13cmos5l_decap_8
XFILLER_28_986 VPWR VGND sg13cmos5l_decap_8
XFILLER_43_934 VPWR VGND sg13cmos5l_decap_8
XFILLER_36_76 VPWR VGND sg13cmos5l_decap_8
XFILLER_15_636 VPWR VGND sg13cmos5l_decap_4
XFILLER_27_474 VPWR VGND sg13cmos5l_decap_8
XFILLER_14_124 VPWR VGND sg13cmos5l_decap_8
XFILLER_15_647 VPWR VGND sg13cmos5l_decap_8
XFILLER_15_658 VPWR VGND sg13cmos5l_fill_1
XFILLER_42_466 VPWR VGND sg13cmos5l_decap_8
XFILLER_11_820 VPWR VGND sg13cmos5l_decap_8
XFILLER_10_330 VPWR VGND sg13cmos5l_decap_4
XFILLER_7_846 VPWR VGND sg13cmos5l_decap_8
XFILLER_42_1015 VPWR VGND sg13cmos5l_decap_8
XFILLER_38_728 VPWR VGND sg13cmos5l_decap_8
XFILLER_18_452 VPWR VGND sg13cmos5l_decap_8
XFILLER_19_986 VPWR VGND sg13cmos5l_decap_8
XFILLER_34_945 VPWR VGND sg13cmos5l_decap_8
XFILLER_33_433 VPWR VGND sg13cmos5l_fill_1
X_1983_ _1983_/Y _2268_/A _1915_/B _2272_/C VPWR VGND sg13cmos5l_o21ai_1
XFILLER_33_499 VPWR VGND sg13cmos5l_decap_4
XFILLER_13_190 VPWR VGND sg13cmos5l_decap_8
XFILLER_20_149 VPWR VGND sg13cmos5l_fill_1
XFILLER_9_172 VPWR VGND sg13cmos5l_decap_8
X_2604_ _2606_/A _2605_/B _2603_/B _2605_/A VPWR VGND sg13cmos5l_a21oi_1
X_2535_ _2535_/Y _2746_/B _2960_/A VPWR VGND sg13cmos5l_nand2_1
X_2466_ _2490_/B _2443_/Y _2465_/B _2619_/B VPWR VGND sg13cmos5l_a21oi_1
XFILLER_3_91 VPWR VGND sg13cmos5l_decap_4
X_2397_ _2397_/Y _2397_/A _2397_/B VPWR VGND sg13cmos5l_xnor2_1
XFILLER_29_717 VPWR VGND sg13cmos5l_decap_8
XFILLER_29_728 VPWR VGND sg13cmos5l_fill_2
XFILLER_29_739 VPWR VGND sg13cmos5l_decap_8
XFILLER_36_271 VPWR VGND sg13cmos5l_decap_8
X_3018_ _3018_/Q clkload4/A _3018_/D fanout167/X VPWR VGND sg13cmos5l_dfrbpq_1
XFILLER_24_444 VPWR VGND sg13cmos5l_decap_8
XFILLER_25_978 VPWR VGND sg13cmos5l_decap_8
XFILLER_40_926 VPWR VGND sg13cmos5l_decap_8
XFILLER_19_1028 VPWR VGND sg13cmos5l_fill_1
XFILLER_11_116 VPWR VGND sg13cmos5l_decap_8
XFILLER_12_639 VPWR VGND sg13cmos5l_decap_4
XFILLER_20_672 VPWR VGND sg13cmos5l_decap_8
XFILLER_20_683 VPWR VGND sg13cmos5l_fill_1
XFILLER_3_315 VPWR VGND sg13cmos5l_decap_8
Xfanout140 _2605_/B hold461/X VPWR VGND sg13cmos5l_buf_1
Xfanout173 fanout173/X fanout176/X VPWR VGND sg13cmos5l_buf_1
Xfanout162 fanout162/X fanout166/X VPWR VGND sg13cmos5l_buf_1
Xfanout151 fanout151/X fanout166/X VPWR VGND sg13cmos5l_buf_1
XFILLER_19_227 VPWR VGND sg13cmos5l_decap_8
XFILLER_15_411 VPWR VGND sg13cmos5l_decap_8
XFILLER_16_923 VPWR VGND sg13cmos5l_decap_8
XFILLER_27_271 VPWR VGND sg13cmos5l_decap_8
XFILLER_28_772 VPWR VGND sg13cmos5l_fill_1
XFILLER_27_282 VPWR VGND sg13cmos5l_fill_1
XFILLER_30_403 VPWR VGND sg13cmos5l_decap_8
XFILLER_31_948 VPWR VGND sg13cmos5l_decap_8
XFILLER_8_58 VPWR VGND sg13cmos5l_decap_8
XFILLER_11_650 VPWR VGND sg13cmos5l_decap_8
XFILLER_7_632 VPWR VGND sg13cmos5l_decap_8
XFILLER_11_661 VPWR VGND sg13cmos5l_fill_2
XFILLER_11_683 VPWR VGND sg13cmos5l_decap_8
XFILLER_6_142 VPWR VGND sg13cmos5l_fill_2
XFILLER_6_186 VPWR VGND sg13cmos5l_decap_8
X_2320_ _2320_/Y _2047_/C _2319_/Y _2253_/A VPWR VGND sg13cmos5l_a21oi_1
XFILLER_3_882 VPWR VGND sg13cmos5l_decap_8
X_2251_ _2286_/B _2251_/A _2251_/B _2251_/C VPWR VGND sg13cmos5l_nor3_1
XFILLER_26_4 VPWR VGND sg13cmos5l_decap_8
X_2182_ _2182_/Y _1866_/Y _2259_/B _2221_/A VPWR VGND sg13cmos5l_nand3b_1
XFILLER_19_750 VPWR VGND sg13cmos5l_decap_4
Xclkbuf_4_1_0_clk clkbuf_4_1_0_clk/X clkbuf_0_clk/X VPWR VGND sg13cmos5l_buf_8
XFILLER_19_761 VPWR VGND sg13cmos5l_fill_2
XFILLER_46_580 VPWR VGND sg13cmos5l_decap_4
XFILLER_33_230 VPWR VGND sg13cmos5l_fill_1
XFILLER_34_742 VPWR VGND sg13cmos5l_decap_8
XFILLER_33_252 VPWR VGND sg13cmos5l_fill_1
X_1966_ _2003_/C _2078_/B _1966_/B VPWR VGND sg13cmos5l_nor2_1
XFILLER_21_458 VPWR VGND sg13cmos5l_decap_8
XFILLER_30_981 VPWR VGND sg13cmos5l_decap_8
X_1897_ _1897_/Y _2149_/B _2147_/A VPWR VGND sg13cmos5l_nand2b_1
X_2518_ _2518_/Y _2518_/A _2529_/A VPWR VGND sg13cmos5l_nand2_1
XFILLER_0_329 VPWR VGND sg13cmos5l_decap_8
X_2449_ _2449_/Y _3023_/Q _2964_/A1 VPWR VGND sg13cmos5l_nor2b_1
XFILLER_29_536 VPWR VGND sg13cmos5l_decap_8
XFILLER_13_904 VPWR VGND sg13cmos5l_decap_8
XFILLER_25_764 VPWR VGND sg13cmos5l_decap_8
XFILLER_12_414 VPWR VGND sg13cmos5l_decap_8
XFILLER_9_919 VPWR VGND sg13cmos5l_decap_8
XFILLER_8_429 VPWR VGND sg13cmos5l_decap_8
XFILLER_32_1025 VPWR VGND sg13cmos5l_decap_4
XFILLER_4_657 VPWR VGND sg13cmos5l_decap_8
XFILLER_3_123 VPWR VGND sg13cmos5l_decap_8
XFILLER_3_167 VPWR VGND sg13cmos5l_fill_1
XFILLER_3_189 VPWR VGND sg13cmos5l_decap_8
XFILLER_0_852 VPWR VGND sg13cmos5l_decap_8
XFILLER_48_823 VPWR VGND sg13cmos5l_decap_8
XFILLER_35_528 VPWR VGND sg13cmos5l_decap_8
XFILLER_16_720 VPWR VGND sg13cmos5l_decap_8
XFILLER_16_775 VPWR VGND sg13cmos5l_fill_1
XFILLER_43_594 VPWR VGND sg13cmos5l_decap_8
XFILLER_15_296 VPWR VGND sg13cmos5l_fill_2
XFILLER_30_211 VPWR VGND sg13cmos5l_decap_8
XFILLER_31_745 VPWR VGND sg13cmos5l_decap_8
X_1820_ _1823_/B _3128_/Q _1821_/B VPWR VGND sg13cmos5l_nand2_1
XFILLER_30_266 VPWR VGND sg13cmos5l_decap_4
XFILLER_8_963 VPWR VGND sg13cmos5l_decap_8
X_1751_ _1755_/B _1751_/A _1752_/B VPWR VGND sg13cmos5l_and2_1
Xhold407 hold407/X _3011_/Q VPWR VGND sg13cmos5l_dlygate4sd3_1
Xhold418 _1504_/A _3031_/Q VPWR VGND sg13cmos5l_dlygate4sd3_1
XFILLER_7_462 VPWR VGND sg13cmos5l_decap_4
X_1682_ _1683_/B _1696_/B _1608_/C _1693_/A VPWR VGND sg13cmos5l_o21ai_1
Xhold429 _2328_/C _3111_/Q VPWR VGND sg13cmos5l_dlygate4sd3_1
X_2303_ _2303_/Y _2285_/B _2301_/Y _2302_/Y _2263_/A VPWR VGND sg13cmos5l_a22oi_1
X_2234_ _2234_/Y _2300_/A _2234_/B VPWR VGND sg13cmos5l_nor2_1
XFILLER_39_856 VPWR VGND sg13cmos5l_decap_8
XFILLER_17_0 VPWR VGND sg13cmos5l_decap_8
X_2165_ _2165_/X _2251_/A _2251_/B VPWR VGND sg13cmos5l_and2_1
X_2096_ _2097_/B _2270_/A _2169_/B _2300_/B VPWR VGND sg13cmos5l_o21ai_1
XFILLER_41_509 VPWR VGND sg13cmos5l_fill_2
XFILLER_0_81 VPWR VGND sg13cmos5l_decap_8
XFILLER_21_211 VPWR VGND sg13cmos5l_fill_2
X_2998_ _2998_/Q _3103_/CLK _2998_/D fanout161/X VPWR VGND sg13cmos5l_dfrbpq_1
XFILLER_21_277 VPWR VGND sg13cmos5l_decap_8
X_1949_ _2403_/B _2402_/A _2323_/A VPWR VGND sg13cmos5l_nand2_1
XFILLER_0_137 VPWR VGND sg13cmos5l_decap_8
XFILLER_29_311 VPWR VGND sg13cmos5l_fill_1
XFILLER_28_77 VPWR VGND sg13cmos5l_decap_8
XFILLER_29_388 VPWR VGND sg13cmos5l_decap_8
XFILLER_44_336 VPWR VGND sg13cmos5l_decap_8
XFILLER_44_21 VPWR VGND sg13cmos5l_decap_4
XFILLER_13_712 VPWR VGND sg13cmos5l_fill_2
XFILLER_9_716 VPWR VGND sg13cmos5l_decap_8
XFILLER_13_756 VPWR VGND sg13cmos5l_fill_2
XFILLER_40_564 VPWR VGND sg13cmos5l_decap_8
XFILLER_8_226 VPWR VGND sg13cmos5l_decap_8
XFILLER_8_259 VPWR VGND sg13cmos5l_decap_8
XFILLER_5_944 VPWR VGND sg13cmos5l_decap_8
XFILLER_4_421 VPWR VGND sg13cmos5l_fill_1
XFILLER_4_410 VPWR VGND sg13cmos5l_decap_8
XFILLER_4_498 VPWR VGND sg13cmos5l_decap_4
XFILLER_36_859 VPWR VGND sg13cmos5l_decap_8
X_2921_ _2921_/X _3030_/Q _3031_/Q _2922_/C VPWR VGND sg13cmos5l_or3_1
XFILLER_16_594 VPWR VGND sg13cmos5l_fill_2
X_2852_ _2852_/Y _2850_/A _2851_/B _2851_/Y VPWR VGND sg13cmos5l_o21ai_1
XFILLER_31_564 VPWR VGND sg13cmos5l_decap_8
X_1803_ _1814_/B _3065_/Q _2929_/B VPWR VGND sg13cmos5l_xnor2_1
X_2783_ _2806_/B _2810_/A _2851_/B VPWR VGND sg13cmos5l_and2_1
XFILLER_8_760 VPWR VGND sg13cmos5l_decap_8
X_1734_ _1737_/B _1720_/A _1732_/Y _1733_/Y VPWR VGND sg13cmos5l_a21oi_1
Xhold226 _2522_/A _2983_/Q VPWR VGND sg13cmos5l_dlygate4sd3_1
Xhold215 _3067_/D _2870_/Y VPWR VGND sg13cmos5l_dlygate4sd3_1
Xhold204 _2439_/A _3094_/Q VPWR VGND sg13cmos5l_dlygate4sd3_1
Xhold259 _2382_/B _2380_/Y VPWR VGND sg13cmos5l_dlygate4sd3_1
X_1665_ _1736_/B _1693_/B _1722_/D VPWR VGND sg13cmos5l_or2_1
Xhold248 _2470_/A _2973_/Q VPWR VGND sg13cmos5l_dlygate4sd3_1
Xhold237 _2621_/A _3025_/Q VPWR VGND sg13cmos5l_dlygate4sd3_1
X_1596_ _1598_/C _3131_/Q _3130_/Q VPWR VGND sg13cmos5l_nand2_1
XFILLER_39_642 VPWR VGND sg13cmos5l_decap_8
X_2217_ _2218_/C _2212_/B _2178_/A _2215_/Y _2194_/B VPWR VGND sg13cmos5l_a22oi_1
Xheichips26_daftASIC_185 uio_out[7] VPWR VGND sg13cmos5l_tielo
XFILLER_22_1002 VPWR VGND sg13cmos5l_decap_8
XFILLER_39_675 VPWR VGND sg13cmos5l_decap_8
XFILLER_38_141 VPWR VGND sg13cmos5l_fill_2
XFILLER_27_826 VPWR VGND sg13cmos5l_fill_1
X_2148_ _2148_/Y _2148_/A _2148_/B VPWR VGND sg13cmos5l_nor2_1
XFILLER_26_314 VPWR VGND sg13cmos5l_fill_1
XFILLER_26_325 VPWR VGND sg13cmos5l_decap_8
X_2079_ _2082_/B _2148_/A _2149_/B _2151_/C VPWR VGND sg13cmos5l_nor3_1
XFILLER_22_520 VPWR VGND sg13cmos5l_decap_8
XFILLER_14_68 VPWR VGND sg13cmos5l_decap_8
XFILLER_5_218 VPWR VGND sg13cmos5l_decap_8
XFILLER_30_56 VPWR VGND sg13cmos5l_decap_8
XFILLER_2_936 VPWR VGND sg13cmos5l_decap_8
XFILLER_1_424 VPWR VGND sg13cmos5l_decap_4
XFILLER_49_406 VPWR VGND sg13cmos5l_decap_8
XFILLER_7_1007 VPWR VGND sg13cmos5l_decap_8
XFILLER_18_859 VPWR VGND sg13cmos5l_decap_8
XFILLER_45_667 VPWR VGND sg13cmos5l_fill_1
XFILLER_44_199 VPWR VGND sg13cmos5l_fill_2
XFILLER_32_339 VPWR VGND sg13cmos5l_decap_4
XFILLER_25_380 VPWR VGND sg13cmos5l_decap_8
XFILLER_40_361 VPWR VGND sg13cmos5l_decap_8
XFILLER_9_502 VPWR VGND sg13cmos5l_decap_8
XFILLER_9_524 VPWR VGND sg13cmos5l_decap_8
XFILLER_9_579 VPWR VGND sg13cmos5l_decap_8
XFILLER_5_741 VPWR VGND sg13cmos5l_decap_8
XFILLER_4_240 VPWR VGND sg13cmos5l_fill_1
XFILLER_45_1024 VPWR VGND sg13cmos5l_decap_4
Xclkbuf_5_27__f_clk _3050_/CLK clkbuf_4_13_0_clk/X VPWR VGND sg13cmos5l_buf_8
X_3120_ _3120_/Q _3123_/CLK _3120_/D fanout150/X VPWR VGND sg13cmos5l_dfrbpq_1
XFILLER_49_951 VPWR VGND sg13cmos5l_decap_8
X_3051_ _3051_/Q _3061_/CLK _3051_/D fanout173/X VPWR VGND sg13cmos5l_dfrbpq_1
XFILLER_48_472 VPWR VGND sg13cmos5l_decap_8
X_2002_ _2002_/Y _2151_/B _2002_/B VPWR VGND sg13cmos5l_nand2_1
XFILLER_36_678 VPWR VGND sg13cmos5l_decap_4
XFILLER_36_667 VPWR VGND sg13cmos5l_fill_2
XFILLER_24_818 VPWR VGND sg13cmos5l_decap_8
XFILLER_24_829 VPWR VGND sg13cmos5l_fill_1
XFILLER_23_306 VPWR VGND sg13cmos5l_decap_4
XFILLER_23_328 VPWR VGND sg13cmos5l_decap_8
XFILLER_16_380 VPWR VGND sg13cmos5l_decap_8
XFILLER_32_840 VPWR VGND sg13cmos5l_decap_8
X_2904_ _2904_/Y _2903_/A _2903_/B _2914_/C VPWR VGND sg13cmos5l_o21ai_1
X_2835_ _2835_/Y _2836_/A _2836_/B VPWR VGND sg13cmos5l_nor2_1
X_2766_ _2766_/Y _2766_/A _2765_/X VPWR VGND sg13cmos5l_nor2b_1
X_1717_ _1717_/Y _2367_/A _1690_/Y _1713_/Y _1686_/Y _1726_/A VPWR VGND sg13cmos5l_a221oi_1
X_2697_ _2699_/B _1805_/B _2934_/A _3080_/Q VPWR VGND sg13cmos5l_mux2_1
X_1648_ _1648_/Y _1648_/A _1648_/B _1648_/C VPWR VGND sg13cmos5l_nand3_1
X_1579_ _3131_/D _2362_/A _1681_/A VPWR VGND sg13cmos5l_nor2_1
XFILLER_26_111 VPWR VGND sg13cmos5l_decap_8
XFILLER_15_818 VPWR VGND sg13cmos5l_decap_8
XFILLER_42_648 VPWR VGND sg13cmos5l_decap_8
XFILLER_25_89 VPWR VGND sg13cmos5l_decap_8
XFILLER_10_512 VPWR VGND sg13cmos5l_fill_2
XFILLER_6_527 VPWR VGND sg13cmos5l_decap_8
XFILLER_2_733 VPWR VGND sg13cmos5l_decap_8
XFILLER_1_232 VPWR VGND sg13cmos5l_decap_4
XFILLER_49_225 VPWR VGND sg13cmos5l_decap_8
XFILLER_2_38 VPWR VGND sg13cmos5l_decap_8
XFILLER_2_49 VPWR VGND sg13cmos5l_fill_1
XFILLER_18_601 VPWR VGND sg13cmos5l_decap_8
XFILLER_46_932 VPWR VGND sg13cmos5l_decap_8
XFILLER_45_453 VPWR VGND sg13cmos5l_fill_2
XFILLER_45_442 VPWR VGND sg13cmos5l_decap_8
XFILLER_18_678 VPWR VGND sg13cmos5l_fill_2
XFILLER_45_486 VPWR VGND sg13cmos5l_fill_1
XFILLER_17_177 VPWR VGND sg13cmos5l_fill_1
XFILLER_17_188 VPWR VGND sg13cmos5l_decap_8
XFILLER_18_689 VPWR VGND sg13cmos5l_decap_8
XFILLER_33_615 VPWR VGND sg13cmos5l_decap_8
XFILLER_14_840 VPWR VGND sg13cmos5l_decap_4
XFILLER_14_851 VPWR VGND sg13cmos5l_decap_8
XFILLER_17_199 VPWR VGND sg13cmos5l_fill_2
XFILLER_33_648 VPWR VGND sg13cmos5l_fill_2
XFILLER_41_670 VPWR VGND sg13cmos5l_decap_8
XFILLER_9_321 VPWR VGND sg13cmos5l_decap_8
X_2620_ _2620_/Y _2630_/B VPWR VGND sg13cmos5l_inv_1
X_2551_ _2552_/B _2991_/Q _2990_/Q _2551_/C VPWR VGND sg13cmos5l_nand3_1
XFILLER_5_571 VPWR VGND sg13cmos5l_fill_2
X_2482_ _2482_/Y _2488_/A _2459_/A _2635_/B _2468_/Y VPWR VGND sg13cmos5l_a22oi_1
X_1502_ _2641_/A _2956_/A VPWR VGND sg13cmos5l_inv_1
X_3103_ _3103_/Q _3103_/CLK _3103_/D fanout161/X VPWR VGND sg13cmos5l_dfrbpq_1
X_3034_ _3034_/Q _3085_/CLK _3034_/D fanout169/X VPWR VGND sg13cmos5l_dfrbpq_1
XFILLER_37_954 VPWR VGND sg13cmos5l_decap_8
XFILLER_36_464 VPWR VGND sg13cmos5l_decap_4
XFILLER_23_158 VPWR VGND sg13cmos5l_decap_4
XFILLER_23_169 VPWR VGND sg13cmos5l_decap_4
XFILLER_20_821 VPWR VGND sg13cmos5l_decap_8
X_2818_ _2821_/B _3050_/Q _2818_/B _2818_/C VPWR VGND sg13cmos5l_and3_1
X_2749_ _2757_/B _3041_/Q _2749_/B VPWR VGND sg13cmos5l_xnor2_1
XFILLER_47_718 VPWR VGND sg13cmos5l_decap_4
Xclkbuf_5_10__f_clk _3101_/CLK clkbuf_4_5_0_clk/X VPWR VGND sg13cmos5l_buf_8
XFILLER_46_217 VPWR VGND sg13cmos5l_decap_8
XFILLER_27_453 VPWR VGND sg13cmos5l_decap_8
XFILLER_28_965 VPWR VGND sg13cmos5l_decap_8
XFILLER_43_913 VPWR VGND sg13cmos5l_decap_8
XFILLER_42_445 VPWR VGND sg13cmos5l_decap_8
XFILLER_14_147 VPWR VGND sg13cmos5l_decap_8
XFILLER_7_825 VPWR VGND sg13cmos5l_decap_8
XFILLER_10_320 VPWR VGND sg13cmos5l_fill_1
XFILLER_22_180 VPWR VGND sg13cmos5l_decap_8
XFILLER_6_324 VPWR VGND sg13cmos5l_fill_2
XFILLER_11_887 VPWR VGND sg13cmos5l_decap_8
XFILLER_6_346 VPWR VGND sg13cmos5l_decap_8
XFILLER_2_541 VPWR VGND sg13cmos5l_fill_2
XFILLER_2_574 VPWR VGND sg13cmos5l_fill_1
XFILLER_38_707 VPWR VGND sg13cmos5l_decap_8
XFILLER_18_431 VPWR VGND sg13cmos5l_decap_8
XFILLER_19_965 VPWR VGND sg13cmos5l_decap_8
XFILLER_33_412 VPWR VGND sg13cmos5l_decap_8
XFILLER_34_924 VPWR VGND sg13cmos5l_decap_8
XFILLER_21_629 VPWR VGND sg13cmos5l_decap_8
XFILLER_33_467 VPWR VGND sg13cmos5l_decap_4
X_1982_ _1982_/Y _1982_/A _2187_/B VPWR VGND sg13cmos5l_nor2_1
XFILLER_20_106 VPWR VGND sg13cmos5l_fill_2
XFILLER_20_128 VPWR VGND sg13cmos5l_decap_8
XFILLER_9_151 VPWR VGND sg13cmos5l_fill_2
X_2603_ _3017_/D _2605_/B _2603_/B VPWR VGND sg13cmos5l_xor2_1
X_2534_ _2534_/Y _2512_/C _2963_/C _2533_/Y VPWR VGND sg13cmos5l_o21ai_1
XFILLER_47_0 VPWR VGND sg13cmos5l_decap_8
X_2465_ _2617_/B _2619_/B _2465_/B VPWR VGND sg13cmos5l_nor2_1
X_2396_ _2396_/Y _2396_/A _2396_/B _2397_/B VPWR VGND sg13cmos5l_nor3_1
XFILLER_36_250 VPWR VGND sg13cmos5l_decap_4
X_3017_ _3017_/Q clkload4/A _3017_/D fanout167/X VPWR VGND sg13cmos5l_dfrbpq_1
XFILLER_19_1007 VPWR VGND sg13cmos5l_decap_8
XFILLER_24_423 VPWR VGND sg13cmos5l_decap_8
XFILLER_25_957 VPWR VGND sg13cmos5l_decap_8
XFILLER_40_905 VPWR VGND sg13cmos5l_decap_8
XFILLER_12_618 VPWR VGND sg13cmos5l_decap_8
XFILLER_20_651 VPWR VGND sg13cmos5l_decap_8
XFILLER_22_46 VPWR VGND sg13cmos5l_decap_4
XFILLER_20_695 VPWR VGND sg13cmos5l_fill_1
XFILLER_4_839 VPWR VGND sg13cmos5l_decap_8
Xfanout130 _2855_/A _3081_/Q VPWR VGND sg13cmos5l_buf_1
Xfanout163 fanout163/X fanout165/X VPWR VGND sg13cmos5l_buf_1
XFILLER_47_21 VPWR VGND sg13cmos5l_decap_8
Xfanout152 fanout152/X fanout156/X VPWR VGND sg13cmos5l_buf_1
Xfanout141 _1831_/C _3017_/Q VPWR VGND sg13cmos5l_buf_1
Xfanout174 fanout174/X fanout176/X VPWR VGND sg13cmos5l_buf_1
XFILLER_47_43 VPWR VGND sg13cmos5l_decap_4
XFILLER_47_32 VPWR VGND sg13cmos5l_fill_2
XFILLER_19_206 VPWR VGND sg13cmos5l_decap_8
XFILLER_47_559 VPWR VGND sg13cmos5l_fill_2
XFILLER_28_751 VPWR VGND sg13cmos5l_decap_8
XFILLER_16_902 VPWR VGND sg13cmos5l_decap_8
XFILLER_34_209 VPWR VGND sg13cmos5l_decap_4
XFILLER_43_765 VPWR VGND sg13cmos5l_decap_8
XFILLER_42_242 VPWR VGND sg13cmos5l_fill_2
XFILLER_15_467 VPWR VGND sg13cmos5l_decap_8
XFILLER_16_979 VPWR VGND sg13cmos5l_decap_8
XFILLER_31_927 VPWR VGND sg13cmos5l_decap_8
XFILLER_30_437 VPWR VGND sg13cmos5l_decap_8
XFILLER_8_48 VPWR VGND sg13cmos5l_fill_1
XFILLER_10_161 VPWR VGND sg13cmos5l_decap_8
XFILLER_7_666 VPWR VGND sg13cmos5l_decap_8
XFILLER_6_121 VPWR VGND sg13cmos5l_decap_8
XFILLER_40_7 VPWR VGND sg13cmos5l_fill_1
XFILLER_3_861 VPWR VGND sg13cmos5l_decap_8
X_2250_ _2250_/Y _2239_/X _2249_/Y _2273_/A VPWR VGND sg13cmos5l_o21ai_1
XFILLER_38_515 VPWR VGND sg13cmos5l_decap_8
XFILLER_19_4 VPWR VGND sg13cmos5l_decap_8
X_2181_ _2181_/Y _2196_/A _2226_/B VPWR VGND sg13cmos5l_nor2_1
XFILLER_34_710 VPWR VGND sg13cmos5l_decap_8
XFILLER_18_283 VPWR VGND sg13cmos5l_decap_8
XFILLER_18_294 VPWR VGND sg13cmos5l_fill_2
XFILLER_34_721 VPWR VGND sg13cmos5l_decap_8
XFILLER_21_437 VPWR VGND sg13cmos5l_decap_8
XFILLER_33_297 VPWR VGND sg13cmos5l_decap_8
X_1965_ _1965_/Y _2404_/A _1965_/B _1965_/C VPWR VGND sg13cmos5l_nor3_1
XFILLER_30_960 VPWR VGND sg13cmos5l_decap_8
X_1896_ _1896_/Y _2205_/A _2078_/B VPWR VGND sg13cmos5l_nand2_1
X_2517_ _2963_/C _2513_/Y _2516_/Y _2960_/A VPWR VGND sg13cmos5l_a21o_1
X_2448_ _2448_/Y _2448_/A _2472_/B VPWR VGND sg13cmos5l_nor2_1
X_2379_ _2379_/Y _2393_/A _2381_/B _2379_/C VPWR VGND sg13cmos5l_nor3_1
XFILLER_29_515 VPWR VGND sg13cmos5l_decap_8
XFILLER_44_518 VPWR VGND sg13cmos5l_fill_2
XFILLER_17_35 VPWR VGND sg13cmos5l_decap_8
XFILLER_24_220 VPWR VGND sg13cmos5l_decap_4
XFILLER_25_743 VPWR VGND sg13cmos5l_decap_8
XFILLER_24_253 VPWR VGND sg13cmos5l_decap_8
XFILLER_40_713 VPWR VGND sg13cmos5l_decap_4
XFILLER_25_798 VPWR VGND sg13cmos5l_decap_8
XFILLER_24_297 VPWR VGND sg13cmos5l_decap_8
XFILLER_32_1004 VPWR VGND sg13cmos5l_decap_8
XFILLER_33_78 VPWR VGND sg13cmos5l_fill_2
XFILLER_33_89 VPWR VGND sg13cmos5l_decap_8
XFILLER_20_492 VPWR VGND sg13cmos5l_decap_8
XFILLER_4_636 VPWR VGND sg13cmos5l_decap_8
Xclkbuf_5_8__f_clk _3099_/CLK clkbuf_4_4_0_clk/X VPWR VGND sg13cmos5l_buf_8
XFILLER_0_831 VPWR VGND sg13cmos5l_decap_8
XFILLER_48_802 VPWR VGND sg13cmos5l_decap_8
XFILLER_48_879 VPWR VGND sg13cmos5l_decap_8
XFILLER_16_743 VPWR VGND sg13cmos5l_fill_1
XFILLER_43_540 VPWR VGND sg13cmos5l_decap_8
XFILLER_15_275 VPWR VGND sg13cmos5l_decap_8
XFILLER_16_798 VPWR VGND sg13cmos5l_decap_8
XFILLER_31_724 VPWR VGND sg13cmos5l_decap_8
XFILLER_30_245 VPWR VGND sg13cmos5l_decap_8
XFILLER_12_982 VPWR VGND sg13cmos5l_decap_8
X_1750_ _1750_/Y _1662_/C _1746_/Y _1749_/Y VPWR VGND sg13cmos5l_a21oi_1
XFILLER_8_942 VPWR VGND sg13cmos5l_decap_8
Xhold408 _3010_/D _2590_/X VPWR VGND sg13cmos5l_dlygate4sd3_1
X_1681_ _1681_/Y _1681_/A _1729_/B VPWR VGND sg13cmos5l_nand2_1
XFILLER_7_496 VPWR VGND sg13cmos5l_fill_1
Xhold419 _1818_/A _3127_/Q VPWR VGND sg13cmos5l_dlygate4sd3_1
X_2302_ _2302_/Y _2078_/B _2143_/C _2003_/C VPWR VGND sg13cmos5l_a21oi_1
XFILLER_39_835 VPWR VGND sg13cmos5l_decap_8
X_2233_ _2234_/B _2272_/C _2232_/Y _2226_/Y VPWR VGND sg13cmos5l_a21oi_1
X_2164_ _2164_/Y _1943_/A _1966_/B _2163_/Y VPWR VGND sg13cmos5l_a21oi_1
XFILLER_26_507 VPWR VGND sg13cmos5l_decap_4
XFILLER_0_60 VPWR VGND sg13cmos5l_decap_8
XFILLER_0_1013 VPWR VGND sg13cmos5l_decap_8
XFILLER_19_592 VPWR VGND sg13cmos5l_fill_1
X_2095_ _2098_/A _2035_/B _2122_/B _1912_/Y VPWR VGND sg13cmos5l_a21oi_1
XFILLER_22_713 VPWR VGND sg13cmos5l_fill_2
XFILLER_34_595 VPWR VGND sg13cmos5l_decap_8
XFILLER_22_746 VPWR VGND sg13cmos5l_decap_8
X_2997_ _2997_/Q _3009_/CLK _2997_/D fanout161/X VPWR VGND sg13cmos5l_dfrbpq_1
XFILLER_22_779 VPWR VGND sg13cmos5l_decap_4
X_1948_ _2404_/C _2153_/A _2322_/A VPWR VGND sg13cmos5l_nor2_1
X_1879_ _2297_/B _2108_/A _2057_/B VPWR VGND sg13cmos5l_nand2_1
XFILLER_0_116 VPWR VGND sg13cmos5l_decap_8
XFILLER_1_639 VPWR VGND sg13cmos5l_decap_8
XFILLER_29_345 VPWR VGND sg13cmos5l_decap_8
XFILLER_29_378 VPWR VGND sg13cmos5l_decap_4
XFILLER_44_315 VPWR VGND sg13cmos5l_decap_8
XFILLER_44_55 VPWR VGND sg13cmos5l_decap_8
XFILLER_13_735 VPWR VGND sg13cmos5l_decap_8
XFILLER_40_598 VPWR VGND sg13cmos5l_decap_8
XFILLER_12_289 VPWR VGND sg13cmos5l_decap_8
XFILLER_5_923 VPWR VGND sg13cmos5l_decap_8
XFILLER_4_433 VPWR VGND sg13cmos5l_decap_8
Xclkbuf_4_0_0_clk clkbuf_4_0_0_clk/X clkbuf_0_clk/X VPWR VGND sg13cmos5l_buf_8
XFILLER_4_466 VPWR VGND sg13cmos5l_decap_8
XFILLER_48_621 VPWR VGND sg13cmos5l_fill_1
XFILLER_48_610 VPWR VGND sg13cmos5l_decap_4
XFILLER_47_197 VPWR VGND sg13cmos5l_fill_2
XFILLER_36_838 VPWR VGND sg13cmos5l_decap_8
XFILLER_16_540 VPWR VGND sg13cmos5l_decap_8
XFILLER_43_370 VPWR VGND sg13cmos5l_fill_1
X_2920_ _2920_/Y _2920_/A _2920_/B VPWR VGND sg13cmos5l_xnor2_1
XFILLER_43_381 VPWR VGND sg13cmos5l_fill_2
XFILLER_31_543 VPWR VGND sg13cmos5l_decap_8
XFILLER_31_554 VPWR VGND sg13cmos5l_fill_2
X_2851_ _2851_/Y _2851_/A _2851_/B VPWR VGND sg13cmos5l_nand2_1
X_2782_ _2807_/B _2810_/A _2851_/B VPWR VGND sg13cmos5l_nor2_1
X_1802_ _2929_/B _1800_/A _2927_/A _2942_/A VPWR VGND sg13cmos5l_o21ai_1
X_1733_ _1733_/Y _1733_/A _1733_/B VPWR VGND sg13cmos5l_nand2_1
Xhold216 _2956_/A _3082_/Q VPWR VGND sg13cmos5l_dlygate4sd3_1
Xhold205 _3094_/D _2439_/Y VPWR VGND sg13cmos5l_dlygate4sd3_1
Xhold227 _2746_/B _2989_/Q VPWR VGND sg13cmos5l_dlygate4sd3_1
X_1664_ _1722_/D _1726_/D _1696_/C VPWR VGND sg13cmos5l_and2_1
Xhold249 _2973_/D _2471_/Y VPWR VGND sg13cmos5l_dlygate4sd3_1
Xhold238 _3024_/D _2623_/Y VPWR VGND sg13cmos5l_dlygate4sd3_1
X_1595_ _1655_/C _3131_/Q _3130_/Q VPWR VGND sg13cmos5l_or2_1
Xheichips26_daftASIC_186 uo_out[6] VPWR VGND sg13cmos5l_tielo
X_2216_ _2218_/B _2074_/A _2301_/B _2003_/B VPWR VGND sg13cmos5l_a21o_1
X_2147_ _2311_/B _2147_/A _2152_/A VPWR VGND sg13cmos5l_or2_1
X_2078_ _2151_/C _2113_/A _2078_/B _2135_/A VPWR VGND sg13cmos5l_nand3_1
XFILLER_41_318 VPWR VGND sg13cmos5l_decap_8
XFILLER_14_25 VPWR VGND sg13cmos5l_decap_8
XFILLER_14_47 VPWR VGND sg13cmos5l_decap_8
XFILLER_22_565 VPWR VGND sg13cmos5l_decap_8
XFILLER_10_738 VPWR VGND sg13cmos5l_fill_2
XFILLER_2_915 VPWR VGND sg13cmos5l_decap_8
XFILLER_39_77 VPWR VGND sg13cmos5l_decap_8
XFILLER_29_131 VPWR VGND sg13cmos5l_fill_2
XFILLER_45_624 VPWR VGND sg13cmos5l_decap_8
XFILLER_18_838 VPWR VGND sg13cmos5l_decap_8
XFILLER_17_359 VPWR VGND sg13cmos5l_decap_8
XFILLER_13_521 VPWR VGND sg13cmos5l_decap_8
XFILLER_5_720 VPWR VGND sg13cmos5l_decap_8
XFILLER_5_797 VPWR VGND sg13cmos5l_decap_8
XFILLER_4_252 VPWR VGND sg13cmos5l_decap_8
XFILLER_45_1003 VPWR VGND sg13cmos5l_decap_8
XFILLER_49_930 VPWR VGND sg13cmos5l_decap_8
X_3050_ _3050_/Q _3050_/CLK _3050_/D fanout171/X VPWR VGND sg13cmos5l_dfrbpq_1
X_2001_ _2001_/Y _2210_/A _2001_/B _2001_/C VPWR VGND sg13cmos5l_nand3_1
XFILLER_17_893 VPWR VGND sg13cmos5l_decap_8
X_2903_ _2907_/B _2903_/A _2903_/B VPWR VGND sg13cmos5l_and2_1
XFILLER_32_885 VPWR VGND sg13cmos5l_decap_8
X_2834_ _2834_/Y _2843_/A _2834_/B _2836_/B VPWR VGND sg13cmos5l_nor3_1
XFILLER_31_373 VPWR VGND sg13cmos5l_fill_2
X_2765_ _2765_/X _3043_/Q _2778_/B VPWR VGND sg13cmos5l_or2_1
X_2696_ _2696_/Y _2690_/Y _2692_/B _2688_/Y VPWR VGND sg13cmos5l_a21oi_1
X_1716_ _1718_/C _1716_/A _1716_/B VPWR VGND sg13cmos5l_nand2_1
X_1647_ _1648_/C _1645_/Y _1646_/Y _1740_/A VPWR VGND sg13cmos5l_o21ai_1
X_1578_ _1696_/B _1633_/B _1632_/A VPWR VGND sg13cmos5l_nand2_1
XFILLER_27_613 VPWR VGND sg13cmos5l_decap_8
XFILLER_26_145 VPWR VGND sg13cmos5l_decap_8
XFILLER_42_627 VPWR VGND sg13cmos5l_decap_8
XFILLER_23_841 VPWR VGND sg13cmos5l_fill_1
XFILLER_25_68 VPWR VGND sg13cmos5l_decap_8
XFILLER_22_362 VPWR VGND sg13cmos5l_decap_8
XFILLER_6_506 VPWR VGND sg13cmos5l_decap_8
XFILLER_2_712 VPWR VGND sg13cmos5l_decap_8
XFILLER_2_789 VPWR VGND sg13cmos5l_decap_8
XFILLER_46_911 VPWR VGND sg13cmos5l_decap_8
XFILLER_45_421 VPWR VGND sg13cmos5l_decap_8
XFILLER_17_145 VPWR VGND sg13cmos5l_decap_4
XFILLER_18_657 VPWR VGND sg13cmos5l_decap_8
XFILLER_46_988 VPWR VGND sg13cmos5l_decap_8
XFILLER_45_465 VPWR VGND sg13cmos5l_decap_8
XFILLER_32_104 VPWR VGND sg13cmos5l_decap_8
XFILLER_45_498 VPWR VGND sg13cmos5l_decap_8
XFILLER_9_300 VPWR VGND sg13cmos5l_decap_8
XFILLER_13_373 VPWR VGND sg13cmos5l_decap_8
XFILLER_15_90 VPWR VGND sg13cmos5l_decap_8
XFILLER_40_181 VPWR VGND sg13cmos5l_decap_8
XFILLER_9_399 VPWR VGND sg13cmos5l_decap_8
XFILLER_12_1024 VPWR VGND sg13cmos5l_decap_4
X_2550_ _2550_/X _2551_/C _2550_/B VPWR VGND sg13cmos5l_xor2_1
XFILLER_5_550 VPWR VGND sg13cmos5l_decap_8
X_1501_ _2850_/A _1501_/A VPWR VGND sg13cmos5l_inv_1
X_2481_ _2481_/Y _2480_/B _2479_/Y _2480_/Y VPWR VGND sg13cmos5l_a21oi_1
XFILLER_49_4 VPWR VGND sg13cmos5l_decap_8
X_3102_ _3102_/Q clkload2/A _3102_/D fanout154/X VPWR VGND sg13cmos5l_dfrbpq_1
X_3033_ _3033_/Q _3036_/CLK _3033_/D fanout169/X VPWR VGND sg13cmos5l_dfrbpq_1
XFILLER_48_270 VPWR VGND sg13cmos5l_decap_8
XFILLER_37_933 VPWR VGND sg13cmos5l_decap_8
XFILLER_36_421 VPWR VGND sg13cmos5l_decap_8
XFILLER_23_104 VPWR VGND sg13cmos5l_decap_4
XFILLER_24_605 VPWR VGND sg13cmos5l_decap_8
XFILLER_17_690 VPWR VGND sg13cmos5l_decap_8
XFILLER_23_126 VPWR VGND sg13cmos5l_decap_8
XFILLER_24_649 VPWR VGND sg13cmos5l_decap_4
XFILLER_31_181 VPWR VGND sg13cmos5l_decap_8
X_2817_ _2817_/Y _3050_/Q _2818_/C _2818_/B VPWR VGND sg13cmos5l_a21oi_1
XFILLER_20_888 VPWR VGND sg13cmos5l_fill_2
X_2748_ _3040_/D hold441/X _2754_/B _2747_/Y VPWR VGND sg13cmos5l_a21o_1
X_2679_ _2681_/A _2679_/A _2678_/Y VPWR VGND sg13cmos5l_nor2b_1
XFILLER_28_944 VPWR VGND sg13cmos5l_decap_8
XFILLER_27_432 VPWR VGND sg13cmos5l_decap_8
XFILLER_15_627 VPWR VGND sg13cmos5l_decap_4
XFILLER_43_969 VPWR VGND sg13cmos5l_decap_8
XFILLER_42_424 VPWR VGND sg13cmos5l_decap_8
XFILLER_35_1013 VPWR VGND sg13cmos5l_decap_8
XFILLER_14_159 VPWR VGND sg13cmos5l_decap_8
XFILLER_30_619 VPWR VGND sg13cmos5l_fill_2
XFILLER_23_682 VPWR VGND sg13cmos5l_decap_8
XFILLER_7_804 VPWR VGND sg13cmos5l_decap_8
XFILLER_11_844 VPWR VGND sg13cmos5l_decap_8
XFILLER_6_369 VPWR VGND sg13cmos5l_decap_8
XFILLER_7_0 VPWR VGND sg13cmos5l_decap_8
XFILLER_2_520 VPWR VGND sg13cmos5l_fill_1
XFILLER_2_553 VPWR VGND sg13cmos5l_decap_8
XFILLER_2_586 VPWR VGND sg13cmos5l_decap_8
XFILLER_18_410 VPWR VGND sg13cmos5l_decap_8
XFILLER_46_752 VPWR VGND sg13cmos5l_decap_8
XFILLER_19_944 VPWR VGND sg13cmos5l_decap_8
XFILLER_45_240 VPWR VGND sg13cmos5l_decap_8
XFILLER_34_903 VPWR VGND sg13cmos5l_decap_8
XFILLER_33_446 VPWR VGND sg13cmos5l_decap_8
XFILLER_21_608 VPWR VGND sg13cmos5l_decap_8
XFILLER_42_980 VPWR VGND sg13cmos5l_decap_8
X_1981_ _2187_/B _2149_/B _2002_/B VPWR VGND sg13cmos5l_nand2_1
XFILLER_9_130 VPWR VGND sg13cmos5l_decap_8
X_2602_ _3016_/D _2602_/A _2605_/D VPWR VGND sg13cmos5l_xnor2_1
XFILLER_9_196 VPWR VGND sg13cmos5l_decap_8
X_2533_ _2533_/Y _2533_/A _2533_/B VPWR VGND sg13cmos5l_nand2_1
X_2464_ _2465_/B _2634_/S _2464_/B VPWR VGND sg13cmos5l_nand2_1
X_2395_ _2397_/B _2395_/A _2395_/B VPWR VGND sg13cmos5l_and2_1
XFILLER_49_590 VPWR VGND sg13cmos5l_decap_8
XFILLER_37_730 VPWR VGND sg13cmos5l_fill_2
XFILLER_3_1022 VPWR VGND sg13cmos5l_decap_8
XFILLER_37_763 VPWR VGND sg13cmos5l_decap_4
X_3016_ _3016_/Q clkload4/A _3016_/D fanout167/X VPWR VGND sg13cmos5l_dfrbpq_1
XFILLER_24_402 VPWR VGND sg13cmos5l_decap_8
XFILLER_25_936 VPWR VGND sg13cmos5l_decap_8
XFILLER_33_991 VPWR VGND sg13cmos5l_decap_8
XFILLER_20_630 VPWR VGND sg13cmos5l_decap_8
XFILLER_22_25 VPWR VGND sg13cmos5l_decap_8
XFILLER_4_818 VPWR VGND sg13cmos5l_decap_8
XFILLER_0_7 VPWR VGND sg13cmos5l_decap_8
Xfanout120 _2669_/B _2934_/A VPWR VGND sg13cmos5l_buf_1
Xfanout131 _2596_/A _3022_/Q VPWR VGND sg13cmos5l_buf_1
Xfanout153 fanout153/X fanout156/X VPWR VGND sg13cmos5l_buf_1
Xfanout142 _2244_/A _2246_/A VPWR VGND sg13cmos5l_buf_1
Xfanout164 fanout164/X fanout166/X VPWR VGND sg13cmos5l_buf_1
Xfanout175 fanout175/X fanout176/X VPWR VGND sg13cmos5l_buf_1
XFILLER_28_785 VPWR VGND sg13cmos5l_decap_8
XFILLER_43_744 VPWR VGND sg13cmos5l_decap_8
XFILLER_43_722 VPWR VGND sg13cmos5l_decap_8
XFILLER_16_958 VPWR VGND sg13cmos5l_decap_8
XFILLER_42_232 VPWR VGND sg13cmos5l_fill_1
XFILLER_15_446 VPWR VGND sg13cmos5l_decap_8
XFILLER_31_906 VPWR VGND sg13cmos5l_decap_8
XFILLER_8_27 VPWR VGND sg13cmos5l_decap_8
XFILLER_6_100 VPWR VGND sg13cmos5l_decap_8
XFILLER_10_195 VPWR VGND sg13cmos5l_decap_8
XFILLER_12_80 VPWR VGND sg13cmos5l_decap_8
XFILLER_3_840 VPWR VGND sg13cmos5l_decap_8
XFILLER_12_91 VPWR VGND sg13cmos5l_fill_2
XFILLER_2_383 VPWR VGND sg13cmos5l_decap_8
X_2180_ _2226_/B _1943_/A _1917_/B _2251_/A VPWR VGND sg13cmos5l_o21ai_1
XFILLER_18_240 VPWR VGND sg13cmos5l_decap_8
XFILLER_18_262 VPWR VGND sg13cmos5l_decap_8
XFILLER_15_991 VPWR VGND sg13cmos5l_decap_8
XFILLER_21_416 VPWR VGND sg13cmos5l_decap_8
XFILLER_22_939 VPWR VGND sg13cmos5l_decap_8
XFILLER_33_276 VPWR VGND sg13cmos5l_decap_8
X_1964_ _1965_/C _2403_/B _1964_/B VPWR VGND sg13cmos5l_nor2_1
X_1895_ _1903_/B _1895_/A _2301_/B VPWR VGND sg13cmos5l_nor2_1
X_2516_ _2516_/Y _2516_/A _2963_/A _2531_/C VPWR VGND sg13cmos5l_nor3_1
X_2447_ _2472_/B _2619_/B _2447_/B VPWR VGND sg13cmos5l_nor2_1
X_2378_ _2378_/Y _2377_/A _3115_/Q _2377_/C VPWR VGND sg13cmos5l_a21oi_1
XFILLER_17_14 VPWR VGND sg13cmos5l_decap_8
XFILLER_17_58 VPWR VGND sg13cmos5l_decap_4
XFILLER_25_722 VPWR VGND sg13cmos5l_decap_8
XFILLER_13_939 VPWR VGND sg13cmos5l_decap_8
XFILLER_24_276 VPWR VGND sg13cmos5l_decap_8
XFILLER_40_769 VPWR VGND sg13cmos5l_decap_8
XFILLER_12_449 VPWR VGND sg13cmos5l_decap_8
XFILLER_33_57 VPWR VGND sg13cmos5l_decap_8
XFILLER_21_983 VPWR VGND sg13cmos5l_decap_8
XFILLER_3_158 VPWR VGND sg13cmos5l_decap_8
XFILLER_0_810 VPWR VGND sg13cmos5l_decap_8
XFILLER_47_313 VPWR VGND sg13cmos5l_decap_4
XFILLER_0_887 VPWR VGND sg13cmos5l_decap_8
XFILLER_48_858 VPWR VGND sg13cmos5l_decap_8
XFILLER_35_519 VPWR VGND sg13cmos5l_fill_1
XFILLER_35_508 VPWR VGND sg13cmos5l_decap_8
XFILLER_28_593 VPWR VGND sg13cmos5l_decap_8
XFILLER_15_232 VPWR VGND sg13cmos5l_fill_1
XFILLER_16_755 VPWR VGND sg13cmos5l_fill_2
XFILLER_15_298 VPWR VGND sg13cmos5l_fill_1
XFILLER_8_921 VPWR VGND sg13cmos5l_decap_8
XFILLER_12_961 VPWR VGND sg13cmos5l_decap_8
XFILLER_7_442 VPWR VGND sg13cmos5l_fill_1
XFILLER_7_431 VPWR VGND sg13cmos5l_decap_8
XFILLER_23_90 VPWR VGND sg13cmos5l_fill_2
Xhold409 _2617_/A _3023_/Q VPWR VGND sg13cmos5l_dlygate4sd3_1
XFILLER_8_998 VPWR VGND sg13cmos5l_decap_8
X_1680_ _1680_/Y _1739_/B _1739_/C _2362_/A VPWR VGND sg13cmos5l_a21oi_1
XFILLER_48_1012 VPWR VGND sg13cmos5l_decap_8
X_2301_ _2301_/Y _2301_/A _2301_/B VPWR VGND sg13cmos5l_nand2_1
XFILLER_39_803 VPWR VGND sg13cmos5l_decap_8
XFILLER_2_191 VPWR VGND sg13cmos5l_decap_8
X_2232_ _2232_/Y _2232_/A _2232_/B _2232_/C VPWR VGND sg13cmos5l_nand3_1
XFILLER_38_335 VPWR VGND sg13cmos5l_fill_1
XFILLER_38_324 VPWR VGND sg13cmos5l_decap_8
X_2163_ _2163_/Y _2163_/A _2178_/B VPWR VGND sg13cmos5l_nor2_1
X_2094_ _2122_/B _2300_/B _2054_/A _2108_/B _2166_/A VPWR VGND sg13cmos5l_a22oi_1
XFILLER_34_563 VPWR VGND sg13cmos5l_decap_8
XFILLER_34_574 VPWR VGND sg13cmos5l_fill_2
XFILLER_10_909 VPWR VGND sg13cmos5l_decap_8
XFILLER_21_213 VPWR VGND sg13cmos5l_fill_1
XFILLER_22_758 VPWR VGND sg13cmos5l_decap_8
X_2996_ _2996_/Q _3008_/CLK _2996_/D fanout161/X VPWR VGND sg13cmos5l_dfrbpq_1
X_1947_ _1965_/B _1932_/Y _1946_/Y _2005_/A VPWR VGND sg13cmos5l_a21oi_1
XFILLER_30_780 VPWR VGND sg13cmos5l_decap_8
X_1878_ _1878_/Y _2308_/A _2186_/C VPWR VGND sg13cmos5l_nor2_1
XFILLER_1_618 VPWR VGND sg13cmos5l_decap_8
XFILLER_28_35 VPWR VGND sg13cmos5l_decap_8
XFILLER_45_806 VPWR VGND sg13cmos5l_decap_8
XFILLER_29_357 VPWR VGND sg13cmos5l_decap_8
XFILLER_38_880 VPWR VGND sg13cmos5l_decap_8
XFILLER_44_34 VPWR VGND sg13cmos5l_decap_8
XFILLER_25_585 VPWR VGND sg13cmos5l_fill_1
XFILLER_12_257 VPWR VGND sg13cmos5l_decap_8
XFILLER_5_902 VPWR VGND sg13cmos5l_decap_8
XFILLER_5_979 VPWR VGND sg13cmos5l_decap_8
XFILLER_5_39 VPWR VGND sg13cmos5l_decap_8
XFILLER_47_121 VPWR VGND sg13cmos5l_fill_2
XFILLER_0_684 VPWR VGND sg13cmos5l_decap_8
XFILLER_36_817 VPWR VGND sg13cmos5l_decap_8
XFILLER_35_327 VPWR VGND sg13cmos5l_decap_8
XFILLER_44_883 VPWR VGND sg13cmos5l_decap_8
XFILLER_16_596 VPWR VGND sg13cmos5l_fill_1
X_2850_ _2850_/Y _2850_/A _2850_/B VPWR VGND sg13cmos5l_xnor2_1
XFILLER_31_522 VPWR VGND sg13cmos5l_decap_8
X_1801_ _2942_/A _2934_/A _2686_/C VPWR VGND sg13cmos5l_or2_1
X_2781_ _2781_/Y _2779_/X _2780_/Y _2776_/Y VPWR VGND sg13cmos5l_o21ai_1
XFILLER_12_791 VPWR VGND sg13cmos5l_fill_2
X_1732_ _1732_/Y _1646_/B _1732_/B _1732_/C VPWR VGND sg13cmos5l_nand3b_1
Xhold206 _2570_/A _2994_/Q VPWR VGND sg13cmos5l_dlygate4sd3_1
XFILLER_8_795 VPWR VGND sg13cmos5l_decap_8
X_1663_ _1693_/B _1584_/A _1572_/B _1662_/Y VPWR VGND sg13cmos5l_o21ai_1
Xhold217 _2429_/B _3089_/Q VPWR VGND sg13cmos5l_dlygate4sd3_1
Xhold228 _2989_/D _2536_/Y VPWR VGND sg13cmos5l_dlygate4sd3_1
XFILLER_7_294 VPWR VGND sg13cmos5l_fill_2
Xhold239 _2607_/A _3019_/Q VPWR VGND sg13cmos5l_dlygate4sd3_1
X_1594_ _1594_/Y _1722_/C _1588_/Y _1593_/X VPWR VGND sg13cmos5l_o21ai_1
XFILLER_38_110 VPWR VGND sg13cmos5l_decap_4
X_2215_ _2215_/Y _2166_/A _2076_/A _2169_/Y VPWR VGND sg13cmos5l_o21ai_1
XFILLER_38_143 VPWR VGND sg13cmos5l_fill_1
Xheichips26_daftASIC_187 uo_out[7] VPWR VGND sg13cmos5l_tielo
XFILLER_27_817 VPWR VGND sg13cmos5l_decap_8
X_2146_ _2152_/A _2244_/A _2041_/B _2246_/C VPWR VGND sg13cmos5l_o21ai_1
XFILLER_26_305 VPWR VGND sg13cmos5l_decap_8
XFILLER_42_809 VPWR VGND sg13cmos5l_decap_8
XFILLER_35_850 VPWR VGND sg13cmos5l_decap_8
X_2077_ _2082_/A _2323_/B _2077_/B VPWR VGND sg13cmos5l_nand2b_1
XFILLER_19_390 VPWR VGND sg13cmos5l_decap_8
XFILLER_35_894 VPWR VGND sg13cmos5l_decap_8
XFILLER_10_706 VPWR VGND sg13cmos5l_decap_8
X_2979_ _2979_/Q clkload1/A _2979_/D fanout157/X VPWR VGND sg13cmos5l_dfrbpq_1
XFILLER_5_209 VPWR VGND sg13cmos5l_decap_4
XFILLER_30_25 VPWR VGND sg13cmos5l_decap_4
XFILLER_39_34 VPWR VGND sg13cmos5l_decap_8
XFILLER_18_817 VPWR VGND sg13cmos5l_decap_8
XFILLER_44_102 VPWR VGND sg13cmos5l_fill_2
XFILLER_17_305 VPWR VGND sg13cmos5l_decap_8
XFILLER_33_809 VPWR VGND sg13cmos5l_decap_8
XFILLER_32_308 VPWR VGND sg13cmos5l_decap_8
XFILLER_41_886 VPWR VGND sg13cmos5l_decap_4
XFILLER_13_555 VPWR VGND sg13cmos5l_fill_2
XFILLER_9_559 VPWR VGND sg13cmos5l_decap_8
XFILLER_5_776 VPWR VGND sg13cmos5l_decap_8
XFILLER_0_481 VPWR VGND sg13cmos5l_decap_8
XFILLER_1_982 VPWR VGND sg13cmos5l_decap_8
XFILLER_49_986 VPWR VGND sg13cmos5l_decap_8
X_2000_ _2001_/C _2078_/B _2076_/A _1999_/Y VPWR VGND sg13cmos5l_o21ai_1
XFILLER_36_625 VPWR VGND sg13cmos5l_decap_4
XFILLER_35_157 VPWR VGND sg13cmos5l_fill_2
XFILLER_17_872 VPWR VGND sg13cmos5l_fill_1
XFILLER_44_691 VPWR VGND sg13cmos5l_decap_8
XFILLER_16_371 VPWR VGND sg13cmos5l_fill_2
X_2902_ _2902_/Y _2903_/A _2902_/B VPWR VGND sg13cmos5l_nand2_1
X_2833_ _2836_/B _2833_/A _2833_/B VPWR VGND sg13cmos5l_and2_1
X_2764_ _2766_/A _3043_/Q _2778_/B VPWR VGND sg13cmos5l_and2_1
XFILLER_8_570 VPWR VGND sg13cmos5l_decap_4
X_1715_ _1716_/B _2367_/A _1679_/Y _1696_/A VPWR VGND sg13cmos5l_a21oi_1
X_2695_ _3034_/D _2948_/A _2648_/A _2694_/Y VPWR VGND sg13cmos5l_a21oi_1
XFILLER_6_93 VPWR VGND sg13cmos5l_decap_8
X_1646_ _1646_/Y _1693_/A _1646_/B _1646_/C _1646_/D VPWR VGND sg13cmos5l_nor4_1
X_1577_ _1726_/D _1638_/A _1638_/C VPWR VGND sg13cmos5l_nand2_1
XFILLER_39_441 VPWR VGND sg13cmos5l_decap_8
XFILLER_39_485 VPWR VGND sg13cmos5l_decap_8
X_2129_ _2129_/Y _1917_/B _2070_/Y _2110_/Y _2297_/B _2125_/Y VPWR VGND sg13cmos5l_a221oi_1
XFILLER_42_606 VPWR VGND sg13cmos5l_decap_8
XFILLER_25_47 VPWR VGND sg13cmos5l_decap_8
XFILLER_10_514 VPWR VGND sg13cmos5l_fill_1
XFILLER_22_385 VPWR VGND sg13cmos5l_decap_8
XFILLER_41_35 VPWR VGND sg13cmos5l_decap_8
XFILLER_1_223 VPWR VGND sg13cmos5l_decap_4
XFILLER_9_4 VPWR VGND sg13cmos5l_decap_8
XFILLER_2_768 VPWR VGND sg13cmos5l_decap_8
XFILLER_1_289 VPWR VGND sg13cmos5l_decap_8
XFILLER_18_636 VPWR VGND sg13cmos5l_decap_8
XFILLER_46_967 VPWR VGND sg13cmos5l_decap_8
XFILLER_17_135 VPWR VGND sg13cmos5l_decap_4
XFILLER_17_168 VPWR VGND sg13cmos5l_decap_8
XFILLER_33_606 VPWR VGND sg13cmos5l_fill_1
XFILLER_26_680 VPWR VGND sg13cmos5l_decap_8
XFILLER_13_330 VPWR VGND sg13cmos5l_fill_1
XFILLER_14_875 VPWR VGND sg13cmos5l_fill_1
XFILLER_9_356 VPWR VGND sg13cmos5l_decap_8
XFILLER_12_1003 VPWR VGND sg13cmos5l_decap_8
XFILLER_9_378 VPWR VGND sg13cmos5l_decap_8
X_1500_ _1500_/Y _1500_/A VPWR VGND sg13cmos5l_inv_1
X_2480_ _2480_/Y _2480_/A _2480_/B VPWR VGND sg13cmos5l_nor2_1
X_3101_ _3101_/Q _3101_/CLK _3101_/D fanout154/X VPWR VGND sg13cmos5l_dfrbpq_1
XFILLER_49_783 VPWR VGND sg13cmos5l_decap_8
X_3032_ _3032_/Q _3085_/CLK _3032_/D fanout165/X VPWR VGND sg13cmos5l_dfrbpq_1
XFILLER_36_411 VPWR VGND sg13cmos5l_fill_2
XFILLER_37_989 VPWR VGND sg13cmos5l_decap_8
XFILLER_36_488 VPWR VGND sg13cmos5l_fill_2
XFILLER_24_628 VPWR VGND sg13cmos5l_decap_8
XFILLER_32_661 VPWR VGND sg13cmos5l_decap_4
X_2816_ _3050_/D _2822_/A _2816_/B VPWR VGND sg13cmos5l_nor2_1
X_2747_ _2747_/Y _2747_/A _2747_/B _2747_/C VPWR VGND sg13cmos5l_nor3_1
XFILLER_11_16 VPWR VGND sg13cmos5l_decap_8
X_2678_ _2678_/Y _3033_/Q _2678_/B VPWR VGND sg13cmos5l_nand2_1
X_1629_ _1629_/Y _1626_/Y _1627_/Y _1718_/B VPWR VGND sg13cmos5l_a21oi_1
XFILLER_28_1021 VPWR VGND sg13cmos5l_decap_8
XFILLER_39_260 VPWR VGND sg13cmos5l_fill_2
XFILLER_27_411 VPWR VGND sg13cmos5l_decap_8
XFILLER_28_923 VPWR VGND sg13cmos5l_decap_8
XFILLER_36_57 VPWR VGND sg13cmos5l_decap_8
XFILLER_15_606 VPWR VGND sg13cmos5l_decap_8
XFILLER_43_948 VPWR VGND sg13cmos5l_decap_8
XFILLER_14_105 VPWR VGND sg13cmos5l_decap_8
XFILLER_27_488 VPWR VGND sg13cmos5l_decap_8
XFILLER_14_138 VPWR VGND sg13cmos5l_fill_2
XFILLER_23_650 VPWR VGND sg13cmos5l_decap_8
XFILLER_10_300 VPWR VGND sg13cmos5l_decap_4
XFILLER_23_661 VPWR VGND sg13cmos5l_decap_8
XFILLER_6_326 VPWR VGND sg13cmos5l_fill_1
XFILLER_10_366 VPWR VGND sg13cmos5l_decap_4
XFILLER_10_377 VPWR VGND sg13cmos5l_decap_8
XFILLER_10_388 VPWR VGND sg13cmos5l_fill_1
XFILLER_2_532 VPWR VGND sg13cmos5l_fill_2
XFILLER_2_543 VPWR VGND sg13cmos5l_fill_1
XFILLER_37_219 VPWR VGND sg13cmos5l_decap_8
XFILLER_19_923 VPWR VGND sg13cmos5l_decap_8
XFILLER_46_742 VPWR VGND sg13cmos5l_fill_2
XFILLER_46_731 VPWR VGND sg13cmos5l_decap_8
XFILLER_18_466 VPWR VGND sg13cmos5l_decap_8
XFILLER_18_477 VPWR VGND sg13cmos5l_fill_1
XFILLER_34_959 VPWR VGND sg13cmos5l_decap_8
X_1980_ _2002_/B _2186_/B _2138_/A VPWR VGND sg13cmos5l_nor2_1
XFILLER_26_90 VPWR VGND sg13cmos5l_decap_8
XFILLER_14_683 VPWR VGND sg13cmos5l_decap_4
XFILLER_20_108 VPWR VGND sg13cmos5l_fill_1
XFILLER_14_694 VPWR VGND sg13cmos5l_decap_8
X_2601_ _2603_/B _2601_/A _2594_/B VPWR VGND sg13cmos5l_nor2b_1
X_2532_ _2532_/Y _1525_/Y _2533_/B _2529_/Y _2531_/Y VPWR VGND sg13cmos5l_a22oi_1
XFILLER_6_893 VPWR VGND sg13cmos5l_decap_8
XFILLER_5_392 VPWR VGND sg13cmos5l_decap_8
X_2463_ _2463_/Y _2486_/B _2461_/Y hold308/X VPWR VGND sg13cmos5l_a21oi_1
X_2394_ _2396_/B _2392_/A _2395_/B _2353_/S VPWR VGND sg13cmos5l_a21oi_1
XFILLER_3_72 VPWR VGND sg13cmos5l_fill_1
XFILLER_3_1001 VPWR VGND sg13cmos5l_decap_8
XFILLER_28_208 VPWR VGND sg13cmos5l_decap_8
X_3015_ _3015_/Q _3135_/CLK _3015_/D fanout168/X VPWR VGND sg13cmos5l_dfrbpq_1
XFILLER_25_915 VPWR VGND sg13cmos5l_decap_8
XFILLER_37_797 VPWR VGND sg13cmos5l_decap_4
XFILLER_36_285 VPWR VGND sg13cmos5l_fill_2
XFILLER_24_458 VPWR VGND sg13cmos5l_decap_4
XFILLER_24_469 VPWR VGND sg13cmos5l_decap_8
XFILLER_33_970 VPWR VGND sg13cmos5l_decap_8
Xfanout110 _2323_/A _2273_/A VPWR VGND sg13cmos5l_buf_1
Xfanout121 _2934_/A _2442_/A VPWR VGND sg13cmos5l_buf_1
Xfanout165 fanout165/X fanout166/X VPWR VGND sg13cmos5l_buf_1
Xfanout154 fanout154/X fanout156/X VPWR VGND sg13cmos5l_buf_1
Xfanout143 _2246_/A _3016_/Q VPWR VGND sg13cmos5l_buf_1
Xfanout132 _2612_/A hold462/X VPWR VGND sg13cmos5l_buf_1
Xfanout176 fanout176/X fanout177/X VPWR VGND sg13cmos5l_buf_1
XFILLER_47_528 VPWR VGND sg13cmos5l_decap_8
XFILLER_15_425 VPWR VGND sg13cmos5l_decap_8
XFILLER_16_937 VPWR VGND sg13cmos5l_decap_8
XFILLER_30_417 VPWR VGND sg13cmos5l_decap_8
XFILLER_7_646 VPWR VGND sg13cmos5l_decap_8
XFILLER_10_174 VPWR VGND sg13cmos5l_decap_8
XFILLER_11_697 VPWR VGND sg13cmos5l_decap_8
XFILLER_6_167 VPWR VGND sg13cmos5l_fill_1
XFILLER_6_156 VPWR VGND sg13cmos5l_decap_8
XFILLER_3_896 VPWR VGND sg13cmos5l_decap_8
XFILLER_2_362 VPWR VGND sg13cmos5l_decap_8
XFILLER_38_539 VPWR VGND sg13cmos5l_decap_8
XFILLER_46_594 VPWR VGND sg13cmos5l_fill_1
XFILLER_33_200 VPWR VGND sg13cmos5l_decap_4
XFILLER_22_918 VPWR VGND sg13cmos5l_decap_8
XFILLER_34_756 VPWR VGND sg13cmos5l_decap_8
XFILLER_34_778 VPWR VGND sg13cmos5l_decap_8
XFILLER_15_970 VPWR VGND sg13cmos5l_decap_8
XFILLER_18_1020 VPWR VGND sg13cmos5l_decap_8
X_1963_ _1964_/B _2268_/A _1955_/Y _1962_/X _2054_/B _1959_/Y VPWR VGND sg13cmos5l_a221oi_1
X_1894_ _2301_/B _2240_/A _2240_/B VPWR VGND sg13cmos5l_nand2_1
XFILLER_30_995 VPWR VGND sg13cmos5l_decap_8
XFILLER_6_690 VPWR VGND sg13cmos5l_decap_8
X_2515_ _2531_/C _2515_/A _2997_/Q _2515_/C _2515_/D VPWR VGND sg13cmos5l_nor4_1
X_2446_ _2447_/B _2459_/A _2446_/B VPWR VGND sg13cmos5l_nor2_1
XFILLER_25_1013 VPWR VGND sg13cmos5l_decap_8
X_2377_ _2381_/B _2377_/A _2377_/B _2377_/C VPWR VGND sg13cmos5l_and3_1
XFILLER_25_701 VPWR VGND sg13cmos5l_decap_8
XFILLER_37_583 VPWR VGND sg13cmos5l_decap_8
XFILLER_24_200 VPWR VGND sg13cmos5l_decap_8
XFILLER_13_918 VPWR VGND sg13cmos5l_decap_8
XFILLER_40_737 VPWR VGND sg13cmos5l_decap_4
XFILLER_40_726 VPWR VGND sg13cmos5l_fill_2
XFILLER_12_428 VPWR VGND sg13cmos5l_decap_8
XFILLER_25_778 VPWR VGND sg13cmos5l_decap_4
XFILLER_33_36 VPWR VGND sg13cmos5l_decap_8
XFILLER_21_962 VPWR VGND sg13cmos5l_decap_8
XFILLER_0_866 VPWR VGND sg13cmos5l_decap_8
XFILLER_48_837 VPWR VGND sg13cmos5l_decap_8
XFILLER_47_358 VPWR VGND sg13cmos5l_decap_8
XFILLER_16_734 VPWR VGND sg13cmos5l_decap_8
XFILLER_28_572 VPWR VGND sg13cmos5l_decap_8
XFILLER_15_255 VPWR VGND sg13cmos5l_decap_8
XFILLER_15_266 VPWR VGND sg13cmos5l_fill_2
XFILLER_12_940 VPWR VGND sg13cmos5l_decap_8
XFILLER_30_225 VPWR VGND sg13cmos5l_decap_8
XFILLER_31_759 VPWR VGND sg13cmos5l_fill_2
XFILLER_8_900 VPWR VGND sg13cmos5l_decap_8
XFILLER_8_977 VPWR VGND sg13cmos5l_decap_8
X_2300_ _2300_/Y _2300_/A _2300_/B _2300_/C _2300_/D VPWR VGND sg13cmos5l_nand4_1
XFILLER_3_693 VPWR VGND sg13cmos5l_decap_8
XFILLER_2_181 VPWR VGND sg13cmos5l_fill_1
X_2231_ _2232_/C _2231_/A _2231_/B _2231_/C VPWR VGND sg13cmos5l_nand3_1
XFILLER_38_303 VPWR VGND sg13cmos5l_decap_4
XFILLER_24_4 VPWR VGND sg13cmos5l_decap_8
X_2162_ _2178_/B _2308_/B _1856_/Y _1943_/A VPWR VGND sg13cmos5l_a21oi_1
X_2093_ _2093_/Y _2166_/A _2108_/B VPWR VGND sg13cmos5l_nand2_1
XFILLER_47_881 VPWR VGND sg13cmos5l_decap_8
XFILLER_0_95 VPWR VGND sg13cmos5l_decap_8
XFILLER_34_531 VPWR VGND sg13cmos5l_fill_2
X_2995_ _2995_/Q _3008_/CLK _2995_/D fanout161/X VPWR VGND sg13cmos5l_dfrbpq_1
XFILLER_9_71 VPWR VGND sg13cmos5l_decap_8
XFILLER_21_247 VPWR VGND sg13cmos5l_fill_2
X_1946_ _1946_/Y _1946_/A _1945_/Y VPWR VGND sg13cmos5l_nor2b_1
X_1877_ _1877_/Y _2267_/A _2187_/A VPWR VGND sg13cmos5l_nand2_1
X_2429_ _2436_/B _2429_/A _2429_/B _2429_/C VPWR VGND sg13cmos5l_and3_1
XFILLER_17_509 VPWR VGND sg13cmos5l_fill_2
XFILLER_25_542 VPWR VGND sg13cmos5l_decap_8
XFILLER_40_501 VPWR VGND sg13cmos5l_fill_1
XFILLER_12_203 VPWR VGND sg13cmos5l_decap_8
XFILLER_40_534 VPWR VGND sg13cmos5l_decap_8
XFILLER_12_225 VPWR VGND sg13cmos5l_decap_8
XFILLER_21_781 VPWR VGND sg13cmos5l_decap_4
XFILLER_21_792 VPWR VGND sg13cmos5l_decap_8
Xclkbuf_5_16__f_clk _3135_/CLK clkbuf_4_8_0_clk/X VPWR VGND sg13cmos5l_buf_8
XFILLER_5_958 VPWR VGND sg13cmos5l_decap_8
XFILLER_48_601 VPWR VGND sg13cmos5l_fill_2
XFILLER_0_663 VPWR VGND sg13cmos5l_decap_8
XFILLER_35_306 VPWR VGND sg13cmos5l_decap_8
XFILLER_29_881 VPWR VGND sg13cmos5l_decap_8
XFILLER_18_91 VPWR VGND sg13cmos5l_decap_8
XFILLER_44_862 VPWR VGND sg13cmos5l_decap_8
XFILLER_43_383 VPWR VGND sg13cmos5l_fill_1
XFILLER_15_1012 VPWR VGND sg13cmos5l_decap_8
XFILLER_31_578 VPWR VGND sg13cmos5l_decap_8
X_1800_ _2686_/C _1800_/A _2919_/A VPWR VGND sg13cmos5l_nand2_1
X_2780_ _2780_/Y _2779_/A _2779_/B _2645_/Y VPWR VGND sg13cmos5l_o21ai_1
XFILLER_8_774 VPWR VGND sg13cmos5l_decap_8
X_1731_ _1731_/Y _1728_/Y _1730_/Y _3126_/Q VPWR VGND sg13cmos5l_o21ai_1
Xhold207 _2571_/A _2569_/Y VPWR VGND sg13cmos5l_dlygate4sd3_1
XFILLER_7_262 VPWR VGND sg13cmos5l_decap_8
X_1662_ _1662_/Y _1746_/A _1662_/B _1662_/C VPWR VGND sg13cmos5l_nand3_1
Xhold229 _2533_/A _2988_/Q VPWR VGND sg13cmos5l_dlygate4sd3_1
Xhold218 _3090_/D _2428_/X VPWR VGND sg13cmos5l_dlygate4sd3_1
X_1593_ _1593_/X _1816_/A _1726_/C _1732_/C _1709_/B VPWR VGND sg13cmos5l_or4_1
XFILLER_39_623 VPWR VGND sg13cmos5l_fill_2
XFILLER_39_612 VPWR VGND sg13cmos5l_decap_8
X_2214_ _2214_/Y _2206_/Y _2207_/Y _2210_/Y _2213_/Y _1496_/Y VPWR VGND sg13cmos5l_a221oi_1
XFILLER_22_1016 VPWR VGND sg13cmos5l_decap_8
XFILLER_39_656 VPWR VGND sg13cmos5l_fill_1
X_2145_ _2157_/B _2137_/Y _2142_/Y _2144_/Y VPWR VGND sg13cmos5l_o21ai_1
Xheichips26_daftASIC_188 uio_oe[0] VPWR VGND sg13cmos5l_tiehi
XFILLER_22_1027 VPWR VGND sg13cmos5l_fill_2
X_2076_ _2323_/B _2076_/A _2076_/B VPWR VGND sg13cmos5l_nor2_1
XFILLER_26_339 VPWR VGND sg13cmos5l_decap_8
XFILLER_14_38 VPWR VGND sg13cmos5l_decap_4
X_2978_ _2978_/Q _3013_/CLK _2978_/D fanout159/X VPWR VGND sg13cmos5l_dfrbpq_1
X_1929_ _2194_/A _2118_/A _2011_/D _2138_/A VPWR VGND sg13cmos5l_o21ai_1
XFILLER_1_405 VPWR VGND sg13cmos5l_decap_4
XFILLER_29_155 VPWR VGND sg13cmos5l_decap_8
XFILLER_44_125 VPWR VGND sg13cmos5l_decap_8
XFILLER_26_840 VPWR VGND sg13cmos5l_fill_2
XFILLER_44_169 VPWR VGND sg13cmos5l_fill_1
XFILLER_41_810 VPWR VGND sg13cmos5l_decap_8
XFILLER_38_1023 VPWR VGND sg13cmos5l_decap_4
XFILLER_13_501 VPWR VGND sg13cmos5l_decap_8
XFILLER_26_862 VPWR VGND sg13cmos5l_decap_8
XFILLER_26_873 VPWR VGND sg13cmos5l_decap_8
XFILLER_40_320 VPWR VGND sg13cmos5l_fill_2
XFILLER_41_865 VPWR VGND sg13cmos5l_decap_8
XFILLER_9_516 VPWR VGND sg13cmos5l_decap_4
XFILLER_9_538 VPWR VGND sg13cmos5l_decap_8
XFILLER_5_755 VPWR VGND sg13cmos5l_decap_8
XFILLER_4_287 VPWR VGND sg13cmos5l_decap_8
XFILLER_20_92 VPWR VGND sg13cmos5l_decap_8
XFILLER_1_961 VPWR VGND sg13cmos5l_decap_8
XFILLER_0_460 VPWR VGND sg13cmos5l_decap_8
XFILLER_49_965 VPWR VGND sg13cmos5l_decap_8
XFILLER_48_442 VPWR VGND sg13cmos5l_fill_1
XFILLER_36_637 VPWR VGND sg13cmos5l_decap_8
XFILLER_36_604 VPWR VGND sg13cmos5l_decap_8
XFILLER_35_169 VPWR VGND sg13cmos5l_decap_4
XFILLER_17_862 VPWR VGND sg13cmos5l_fill_1
XFILLER_16_394 VPWR VGND sg13cmos5l_decap_8
X_2901_ _2901_/Y _2896_/A _2900_/Y _2898_/Y VPWR VGND sg13cmos5l_o21ai_1
XFILLER_43_191 VPWR VGND sg13cmos5l_fill_1
XFILLER_31_342 VPWR VGND sg13cmos5l_decap_8
X_2832_ _2832_/Y _2833_/A _2833_/B VPWR VGND sg13cmos5l_nor2_1
X_2763_ _2763_/Y _2761_/A _2761_/B _2755_/Y VPWR VGND sg13cmos5l_o21ai_1
X_1714_ _1716_/A _1681_/A _1680_/Y _1712_/Y VPWR VGND sg13cmos5l_o21ai_1
X_2694_ _2694_/Y _2746_/A _2692_/Y _2693_/X VPWR VGND sg13cmos5l_a21oi_1
XFILLER_6_83 VPWR VGND sg13cmos5l_decap_4
X_1645_ _1645_/Y _1726_/A _1732_/C VPWR VGND sg13cmos5l_nor2_1
X_1576_ _1646_/C _1584_/A _1640_/B VPWR VGND sg13cmos5l_nor2_1
XFILLER_39_464 VPWR VGND sg13cmos5l_decap_8
XFILLER_27_626 VPWR VGND sg13cmos5l_decap_8
X_2128_ _2128_/Y _2322_/B _2123_/X _2127_/Y VPWR VGND sg13cmos5l_o21ai_1
XFILLER_26_125 VPWR VGND sg13cmos5l_decap_8
X_2059_ _2059_/Y _2148_/A _2290_/B _2058_/Y _2031_/C _2169_/B VPWR VGND sg13cmos5l_a221oi_1
XFILLER_14_309 VPWR VGND sg13cmos5l_decap_8
XFILLER_25_26 VPWR VGND sg13cmos5l_decap_8
XFILLER_35_692 VPWR VGND sg13cmos5l_decap_8
XFILLER_23_832 VPWR VGND sg13cmos5l_decap_8
XFILLER_22_342 VPWR VGND sg13cmos5l_fill_2
XFILLER_23_865 VPWR VGND sg13cmos5l_fill_2
XFILLER_41_14 VPWR VGND sg13cmos5l_decap_8
XFILLER_10_526 VPWR VGND sg13cmos5l_decap_8
XFILLER_22_375 VPWR VGND sg13cmos5l_decap_4
XFILLER_2_747 VPWR VGND sg13cmos5l_decap_8
XFILLER_1_202 VPWR VGND sg13cmos5l_fill_2
XFILLER_1_257 VPWR VGND sg13cmos5l_decap_8
XFILLER_18_615 VPWR VGND sg13cmos5l_decap_8
XFILLER_46_946 VPWR VGND sg13cmos5l_decap_8
XFILLER_14_821 VPWR VGND sg13cmos5l_fill_2
XFILLER_14_865 VPWR VGND sg13cmos5l_fill_1
XFILLER_25_180 VPWR VGND sg13cmos5l_fill_1
XFILLER_41_684 VPWR VGND sg13cmos5l_decap_8
XFILLER_14_898 VPWR VGND sg13cmos5l_decap_8
XFILLER_9_335 VPWR VGND sg13cmos5l_decap_4
XFILLER_13_397 VPWR VGND sg13cmos5l_decap_8
X_3100_ _3100_/Q clkload2/A _3100_/D fanout154/X VPWR VGND sg13cmos5l_dfrbpq_1
XFILLER_0_290 VPWR VGND sg13cmos5l_decap_8
XFILLER_49_762 VPWR VGND sg13cmos5l_decap_8
X_3031_ _3031_/Q clkload6/A _3031_/D fanout164/X VPWR VGND sg13cmos5l_dfrbpq_1
XFILLER_37_968 VPWR VGND sg13cmos5l_decap_8
XFILLER_16_180 VPWR VGND sg13cmos5l_decap_8
XFILLER_32_651 VPWR VGND sg13cmos5l_fill_1
XFILLER_20_813 VPWR VGND sg13cmos5l_fill_2
X_2815_ _2815_/Y _2815_/A _2818_/C VPWR VGND sg13cmos5l_xnor2_1
XFILLER_20_835 VPWR VGND sg13cmos5l_decap_8
X_2746_ _2747_/C _2746_/A _2746_/B VPWR VGND sg13cmos5l_nor2_1
XFILLER_8_390 VPWR VGND sg13cmos5l_fill_2
XFILLER_9_891 VPWR VGND sg13cmos5l_decap_8
X_2677_ _2679_/A _3033_/Q _2678_/B VPWR VGND sg13cmos5l_nor2_1
X_1628_ _1628_/X _1718_/B _1628_/B _1729_/B _1628_/D VPWR VGND sg13cmos5l_and4_1
XFILLER_28_1000 VPWR VGND sg13cmos5l_decap_8
X_1559_ _1559_/X _1537_/Y _1556_/Y _1557_/X VPWR VGND sg13cmos5l_a21o_1
XFILLER_28_902 VPWR VGND sg13cmos5l_decap_8
XFILLER_36_36 VPWR VGND sg13cmos5l_decap_8
XFILLER_43_927 VPWR VGND sg13cmos5l_decap_8
XFILLER_36_69 VPWR VGND sg13cmos5l_decap_8
XFILLER_27_467 VPWR VGND sg13cmos5l_decap_8
XFILLER_28_979 VPWR VGND sg13cmos5l_decap_8
XFILLER_42_459 VPWR VGND sg13cmos5l_decap_8
XFILLER_11_813 VPWR VGND sg13cmos5l_decap_8
XFILLER_10_334 VPWR VGND sg13cmos5l_fill_1
XFILLER_22_194 VPWR VGND sg13cmos5l_decap_8
XFILLER_7_839 VPWR VGND sg13cmos5l_decap_8
Xhold390 _2996_/D _2575_/Y VPWR VGND sg13cmos5l_dlygate4sd3_1
XFILLER_42_1008 VPWR VGND sg13cmos5l_decap_8
XFILLER_19_902 VPWR VGND sg13cmos5l_decap_8
XFILLER_18_445 VPWR VGND sg13cmos5l_decap_8
XFILLER_19_979 VPWR VGND sg13cmos5l_decap_8
XFILLER_27_990 VPWR VGND sg13cmos5l_decap_8
XFILLER_33_426 VPWR VGND sg13cmos5l_decap_8
XFILLER_34_938 VPWR VGND sg13cmos5l_decap_8
XFILLER_13_161 VPWR VGND sg13cmos5l_decap_8
XFILLER_13_183 VPWR VGND sg13cmos5l_decap_8
XFILLER_9_165 VPWR VGND sg13cmos5l_decap_8
X_2600_ _3015_/D _2600_/A _2615_/A _2605_/D VPWR VGND sg13cmos5l_nor3_1
X_2531_ _2531_/Y _2531_/A _2963_/B _2531_/C VPWR VGND sg13cmos5l_nor3_1
XFILLER_6_872 VPWR VGND sg13cmos5l_decap_8
XFILLER_5_371 VPWR VGND sg13cmos5l_decap_8
X_2462_ _2462_/Y _2462_/A _2486_/B VPWR VGND sg13cmos5l_nor2_1
X_2393_ _3121_/D _2393_/A _2393_/B VPWR VGND sg13cmos5l_nor2_1
XFILLER_3_62 VPWR VGND sg13cmos5l_fill_1
XFILLER_3_51 VPWR VGND sg13cmos5l_decap_8
XFILLER_49_570 VPWR VGND sg13cmos5l_fill_2
XFILLER_3_95 VPWR VGND sg13cmos5l_fill_2
XFILLER_3_84 VPWR VGND sg13cmos5l_decap_8
XFILLER_37_732 VPWR VGND sg13cmos5l_fill_1
X_3014_ _3014_/Q _3135_/CLK _3014_/D fanout168/X VPWR VGND sg13cmos5l_dfrbpq_1
XFILLER_36_264 VPWR VGND sg13cmos5l_decap_8
XFILLER_40_919 VPWR VGND sg13cmos5l_decap_8
XFILLER_24_437 VPWR VGND sg13cmos5l_decap_8
XFILLER_11_109 VPWR VGND sg13cmos5l_decap_8
XFILLER_20_621 VPWR VGND sg13cmos5l_fill_1
XFILLER_20_665 VPWR VGND sg13cmos5l_decap_8
X_2729_ _2729_/X _2741_/A _2741_/B VPWR VGND sg13cmos5l_xor2_1
XFILLER_3_308 VPWR VGND sg13cmos5l_decap_8
Xfanout111 _2300_/A _2273_/A VPWR VGND sg13cmos5l_buf_1
Xfanout100 _1718_/B _3126_/Q VPWR VGND sg13cmos5l_buf_1
Xfanout122 _2442_/A _2964_/A1 VPWR VGND sg13cmos5l_buf_1
Xfanout155 fanout155/X fanout156/X VPWR VGND sg13cmos5l_buf_1
Xfanout133 _2596_/C hold463/X VPWR VGND sg13cmos5l_buf_1
Xfanout144 _1861_/A _2244_/B VPWR VGND sg13cmos5l_buf_1
Xfanout177 fanout177/X fanout178/X VPWR VGND sg13cmos5l_buf_1
Xfanout166 fanout166/X fanout178/X VPWR VGND sg13cmos5l_buf_1
XFILLER_28_732 VPWR VGND sg13cmos5l_decap_8
XFILLER_43_702 VPWR VGND sg13cmos5l_fill_1
XFILLER_16_916 VPWR VGND sg13cmos5l_decap_8
XFILLER_15_404 VPWR VGND sg13cmos5l_decap_8
XFILLER_27_264 VPWR VGND sg13cmos5l_decap_8
XFILLER_42_289 VPWR VGND sg13cmos5l_decap_8
XFILLER_11_621 VPWR VGND sg13cmos5l_decap_8
XFILLER_24_993 VPWR VGND sg13cmos5l_decap_8
XFILLER_7_625 VPWR VGND sg13cmos5l_decap_8
XFILLER_11_643 VPWR VGND sg13cmos5l_decap_8
XFILLER_6_135 VPWR VGND sg13cmos5l_fill_2
XFILLER_6_179 VPWR VGND sg13cmos5l_decap_8
XFILLER_2_330 VPWR VGND sg13cmos5l_decap_8
XFILLER_3_875 VPWR VGND sg13cmos5l_decap_8
XFILLER_38_529 VPWR VGND sg13cmos5l_decap_4
XFILLER_19_743 VPWR VGND sg13cmos5l_decap_8
XFILLER_19_754 VPWR VGND sg13cmos5l_fill_2
XFILLER_46_584 VPWR VGND sg13cmos5l_fill_1
XFILLER_46_573 VPWR VGND sg13cmos5l_decap_8
XFILLER_19_798 VPWR VGND sg13cmos5l_decap_8
XFILLER_34_735 VPWR VGND sg13cmos5l_decap_8
XFILLER_33_245 VPWR VGND sg13cmos5l_fill_2
X_1962_ _1962_/X _2190_/C _2235_/B VPWR VGND sg13cmos5l_or2_1
X_1893_ _1895_/A _2272_/C _2205_/A VPWR VGND sg13cmos5l_nand2_1
XFILLER_30_974 VPWR VGND sg13cmos5l_decap_8
X_2514_ _2514_/Y _2515_/A _2997_/Q VPWR VGND sg13cmos5l_nor2_1
X_2445_ _2446_/B _3028_/Q _3029_/Q VPWR VGND sg13cmos5l_nor2_1
X_2376_ _3115_/D _2393_/A _2376_/B VPWR VGND sg13cmos5l_nor2_1
XFILLER_29_529 VPWR VGND sg13cmos5l_decap_8
XFILLER_37_562 VPWR VGND sg13cmos5l_decap_8
XFILLER_25_757 VPWR VGND sg13cmos5l_decap_8
XFILLER_12_407 VPWR VGND sg13cmos5l_decap_8
XFILLER_24_267 VPWR VGND sg13cmos5l_fill_1
XFILLER_21_941 VPWR VGND sg13cmos5l_decap_8
XFILLER_32_1018 VPWR VGND sg13cmos5l_decap_8
XFILLER_3_116 VPWR VGND sg13cmos5l_decap_8
XFILLER_0_845 VPWR VGND sg13cmos5l_decap_8
XFILLER_48_816 VPWR VGND sg13cmos5l_decap_8
XFILLER_47_337 VPWR VGND sg13cmos5l_fill_2
XFILLER_47_348 VPWR VGND sg13cmos5l_decap_4
XFILLER_15_212 VPWR VGND sg13cmos5l_decap_8
XFILLER_16_768 VPWR VGND sg13cmos5l_fill_2
XFILLER_43_587 VPWR VGND sg13cmos5l_decap_8
XFILLER_43_554 VPWR VGND sg13cmos5l_fill_2
XFILLER_15_289 VPWR VGND sg13cmos5l_decap_8
XFILLER_31_738 VPWR VGND sg13cmos5l_decap_8
XFILLER_30_259 VPWR VGND sg13cmos5l_decap_8
XFILLER_8_956 VPWR VGND sg13cmos5l_decap_8
XFILLER_12_996 VPWR VGND sg13cmos5l_decap_8
XFILLER_7_455 VPWR VGND sg13cmos5l_decap_8
XFILLER_11_495 VPWR VGND sg13cmos5l_decap_8
XFILLER_3_672 VPWR VGND sg13cmos5l_decap_8
X_2230_ _2231_/C _1989_/B _2118_/B _2178_/B VPWR VGND sg13cmos5l_o21ai_1
XFILLER_39_849 VPWR VGND sg13cmos5l_decap_8
X_2161_ _2338_/A _2089_/Y _2160_/X _3109_/Q VPWR VGND sg13cmos5l_a21oi_1
XFILLER_47_860 VPWR VGND sg13cmos5l_decap_8
X_2092_ _2108_/B _2183_/A _2183_/B _2118_/B VPWR VGND sg13cmos5l_nand3b_1
XFILLER_0_1027 VPWR VGND sg13cmos5l_fill_2
XFILLER_0_74 VPWR VGND sg13cmos5l_decap_8
X_2994_ _2994_/Q _3009_/CLK _2994_/D fanout157/X VPWR VGND sg13cmos5l_dfrbpq_1
XFILLER_15_790 VPWR VGND sg13cmos5l_decap_8
XFILLER_21_204 VPWR VGND sg13cmos5l_decap_8
XFILLER_21_237 VPWR VGND sg13cmos5l_decap_4
XFILLER_9_50 VPWR VGND sg13cmos5l_fill_2
X_1945_ _1945_/Y _2231_/A _1945_/B _2251_/B VPWR VGND sg13cmos5l_nand3_1
XFILLER_30_760 VPWR VGND sg13cmos5l_decap_8
X_1876_ _2187_/A _2308_/A _2240_/C VPWR VGND sg13cmos5l_nand2_1
X_2428_ _2428_/X _3090_/Q _2429_/B VPWR VGND sg13cmos5l_xor2_1
X_2359_ _3157_/A _3087_/Q _2358_/X _2350_/Y VPWR VGND sg13cmos5l_a21oi_1
XFILLER_29_304 VPWR VGND sg13cmos5l_decap_8
XFILLER_44_329 VPWR VGND sg13cmos5l_decap_8
XFILLER_44_14 VPWR VGND sg13cmos5l_decap_8
XFILLER_25_521 VPWR VGND sg13cmos5l_decap_8
XFILLER_13_705 VPWR VGND sg13cmos5l_decap_8
XFILLER_9_709 VPWR VGND sg13cmos5l_decap_8
XFILLER_13_749 VPWR VGND sg13cmos5l_decap_8
XFILLER_40_557 VPWR VGND sg13cmos5l_decap_8
XFILLER_5_937 VPWR VGND sg13cmos5l_decap_8
XFILLER_4_403 VPWR VGND sg13cmos5l_decap_8
XFILLER_4_447 VPWR VGND sg13cmos5l_fill_2
XFILLER_0_642 VPWR VGND sg13cmos5l_decap_8
XFILLER_29_860 VPWR VGND sg13cmos5l_decap_8
XFILLER_44_841 VPWR VGND sg13cmos5l_decap_8
XFILLER_16_510 VPWR VGND sg13cmos5l_decap_4
XFILLER_16_554 VPWR VGND sg13cmos5l_fill_1
XFILLER_16_565 VPWR VGND sg13cmos5l_decap_8
XFILLER_31_502 VPWR VGND sg13cmos5l_fill_1
XFILLER_34_91 VPWR VGND sg13cmos5l_fill_1
XFILLER_12_771 VPWR VGND sg13cmos5l_decap_8
XFILLER_8_753 VPWR VGND sg13cmos5l_decap_8
XFILLER_7_241 VPWR VGND sg13cmos5l_decap_8
XFILLER_11_292 VPWR VGND sg13cmos5l_decap_4
X_1730_ _1730_/Y _1720_/A _1613_/Y _1729_/Y VPWR VGND sg13cmos5l_a21oi_1
Xhold208 _2377_/A _3114_/Q VPWR VGND sg13cmos5l_dlygate4sd3_1
X_1661_ _1662_/C _1831_/C _1661_/B VPWR VGND sg13cmos5l_nand2_1
XFILLER_7_296 VPWR VGND sg13cmos5l_fill_1
XFILLER_7_285 VPWR VGND sg13cmos5l_decap_4
Xhold219 _2429_/C _3091_/Q VPWR VGND sg13cmos5l_dlygate4sd3_1
X_1592_ _1687_/B _1604_/A _1632_/A VPWR VGND sg13cmos5l_nand2_1
XFILLER_3_491 VPWR VGND sg13cmos5l_decap_8
XFILLER_39_635 VPWR VGND sg13cmos5l_decap_8
X_2213_ _2213_/Y _2294_/A _2213_/B _2213_/C _2221_/B VPWR VGND sg13cmos5l_nor4_1
X_2144_ _2144_/Y _2323_/A _2322_/B _2144_/C VPWR VGND sg13cmos5l_nor3_1
Xheichips26_daftASIC_189 uio_oe[1] VPWR VGND sg13cmos5l_tiehi
X_2075_ _2156_/B _2054_/A _2054_/B _2074_/Y _2113_/A VPWR VGND sg13cmos5l_a22oi_1
Xclkbuf_5_22__f_clk _3072_/CLK clkbuf_4_11_0_clk/X VPWR VGND sg13cmos5l_buf_8
XFILLER_22_513 VPWR VGND sg13cmos5l_decap_8
XFILLER_22_535 VPWR VGND sg13cmos5l_fill_2
XFILLER_34_373 VPWR VGND sg13cmos5l_decap_4
XFILLER_22_579 VPWR VGND sg13cmos5l_decap_4
X_2977_ _2977_/Q _3122_/CLK _2977_/D fanout153/X VPWR VGND sg13cmos5l_dfrbpq_1
X_1928_ _2036_/B _2244_/C _2308_/D _1907_/A VPWR VGND sg13cmos5l_a21oi_1
XFILLER_30_590 VPWR VGND sg13cmos5l_fill_2
X_1859_ _2270_/A _2078_/B _2227_/A VPWR VGND sg13cmos5l_nor2_1
XFILLER_30_49 VPWR VGND sg13cmos5l_decap_8
XFILLER_2_929 VPWR VGND sg13cmos5l_decap_8
XFILLER_1_428 VPWR VGND sg13cmos5l_fill_1
XFILLER_45_605 VPWR VGND sg13cmos5l_fill_1
XFILLER_44_148 VPWR VGND sg13cmos5l_fill_2
XFILLER_38_1002 VPWR VGND sg13cmos5l_decap_8
XFILLER_13_535 VPWR VGND sg13cmos5l_fill_2
XFILLER_25_373 VPWR VGND sg13cmos5l_decap_8
XFILLER_5_734 VPWR VGND sg13cmos5l_decap_8
XFILLER_4_222 VPWR VGND sg13cmos5l_decap_8
XFILLER_45_1017 VPWR VGND sg13cmos5l_decap_8
XFILLER_4_277 VPWR VGND sg13cmos5l_decap_4
XFILLER_20_71 VPWR VGND sg13cmos5l_decap_8
XFILLER_45_1028 VPWR VGND sg13cmos5l_fill_1
XFILLER_1_940 VPWR VGND sg13cmos5l_decap_8
XFILLER_49_944 VPWR VGND sg13cmos5l_decap_8
XFILLER_35_126 VPWR VGND sg13cmos5l_fill_2
XFILLER_44_660 VPWR VGND sg13cmos5l_decap_8
XFILLER_35_159 VPWR VGND sg13cmos5l_fill_1
XFILLER_16_351 VPWR VGND sg13cmos5l_decap_8
XFILLER_45_90 VPWR VGND sg13cmos5l_decap_8
XFILLER_44_671 VPWR VGND sg13cmos5l_fill_2
XFILLER_16_362 VPWR VGND sg13cmos5l_fill_1
XFILLER_16_373 VPWR VGND sg13cmos5l_fill_1
X_2900_ _2900_/Y _2900_/A _2900_/B VPWR VGND sg13cmos5l_xnor2_1
XFILLER_32_833 VPWR VGND sg13cmos5l_decap_8
X_2831_ _3055_/D _2843_/A _2831_/B _2833_/B VPWR VGND sg13cmos5l_nor3_1
XFILLER_32_899 VPWR VGND sg13cmos5l_decap_8
X_2762_ _3042_/D _2645_/Y _2761_/X _2754_/X VPWR VGND sg13cmos5l_a21o_1
X_1713_ _1713_/Y _1687_/B _1739_/B _1711_/Y VPWR VGND sg13cmos5l_o21ai_1
X_2693_ _2693_/X _1500_/A _2522_/A _2730_/B1 VPWR VGND sg13cmos5l_a21o_1
XFILLER_6_62 VPWR VGND sg13cmos5l_decap_8
X_1644_ _1648_/B _1644_/A _1644_/B _1644_/C VPWR VGND sg13cmos5l_nand3_1
X_1575_ _1640_/B _1575_/A _1575_/B VPWR VGND sg13cmos5l_xor2_1
XFILLER_39_410 VPWR VGND sg13cmos5l_decap_8
X_2127_ _2127_/Y _2322_/A _2127_/B VPWR VGND sg13cmos5l_nor2_1
XFILLER_26_104 VPWR VGND sg13cmos5l_decap_8
X_2058_ _2058_/Y _2076_/A _2270_/B VPWR VGND sg13cmos5l_nand2_1
XFILLER_22_321 VPWR VGND sg13cmos5l_decap_8
XFILLER_10_505 VPWR VGND sg13cmos5l_decap_8
XFILLER_23_888 VPWR VGND sg13cmos5l_fill_2
XFILLER_2_726 VPWR VGND sg13cmos5l_decap_8
XFILLER_1_236 VPWR VGND sg13cmos5l_fill_1
XFILLER_49_218 VPWR VGND sg13cmos5l_decap_8
XFILLER_46_925 VPWR VGND sg13cmos5l_decap_8
XFILLER_45_435 VPWR VGND sg13cmos5l_decap_8
XFILLER_45_479 VPWR VGND sg13cmos5l_decap_8
XFILLER_14_800 VPWR VGND sg13cmos5l_decap_8
XFILLER_13_321 VPWR VGND sg13cmos5l_fill_2
XFILLER_13_343 VPWR VGND sg13cmos5l_fill_1
XFILLER_14_844 VPWR VGND sg13cmos5l_fill_2
XFILLER_25_192 VPWR VGND sg13cmos5l_decap_8
XFILLER_41_663 VPWR VGND sg13cmos5l_decap_8
XFILLER_9_314 VPWR VGND sg13cmos5l_decap_8
XFILLER_40_195 VPWR VGND sg13cmos5l_decap_8
XFILLER_13_387 VPWR VGND sg13cmos5l_fill_1
XFILLER_5_531 VPWR VGND sg13cmos5l_fill_2
XFILLER_5_564 VPWR VGND sg13cmos5l_decap_8
XFILLER_5_586 VPWR VGND sg13cmos5l_fill_1
XFILLER_49_741 VPWR VGND sg13cmos5l_decap_8
XFILLER_48_240 VPWR VGND sg13cmos5l_fill_2
X_3030_ _3030_/Q clkload6/A _3030_/D fanout164/X VPWR VGND sg13cmos5l_dfrbpq_1
XFILLER_37_947 VPWR VGND sg13cmos5l_decap_8
XFILLER_36_457 VPWR VGND sg13cmos5l_decap_8
XFILLER_16_170 VPWR VGND sg13cmos5l_fill_2
XFILLER_32_630 VPWR VGND sg13cmos5l_decap_8
X_2814_ _3049_/D _2822_/A _2814_/B _2818_/C VPWR VGND sg13cmos5l_nor3_1
XFILLER_31_195 VPWR VGND sg13cmos5l_fill_1
XFILLER_9_870 VPWR VGND sg13cmos5l_decap_8
X_2745_ _2747_/B _2855_/A _2745_/B VPWR VGND sg13cmos5l_nor2_1
X_2676_ _2678_/B _3080_/Q _2639_/B _2671_/Y VPWR VGND sg13cmos5l_a21o_1
X_1627_ _1627_/Y _1602_/D _1732_/B _1732_/C VPWR VGND sg13cmos5l_nand3b_1
X_1558_ _1584_/A _1537_/Y _1556_/Y _1557_/X VPWR VGND sg13cmos5l_a21oi_1
X_1489_ _1705_/A _3127_/Q VPWR VGND sg13cmos5l_inv_1
X_3159_ _3159_/X _3159_/A VPWR VGND sg13cmos5l_buf_1
XFILLER_28_958 VPWR VGND sg13cmos5l_decap_8
XFILLER_43_906 VPWR VGND sg13cmos5l_decap_8
XFILLER_27_446 VPWR VGND sg13cmos5l_decap_8
XFILLER_42_438 VPWR VGND sg13cmos5l_decap_8
XFILLER_35_1027 VPWR VGND sg13cmos5l_fill_2
XFILLER_11_858 VPWR VGND sg13cmos5l_decap_4
XFILLER_22_173 VPWR VGND sg13cmos5l_decap_8
XFILLER_23_696 VPWR VGND sg13cmos5l_decap_8
XFILLER_7_818 VPWR VGND sg13cmos5l_decap_8
XFILLER_6_317 VPWR VGND sg13cmos5l_decap_8
XFILLER_10_346 VPWR VGND sg13cmos5l_decap_4
XFILLER_6_339 VPWR VGND sg13cmos5l_decap_8
Xhold380 _2807_/A _3047_/Q VPWR VGND sg13cmos5l_dlygate4sd3_1
XFILLER_2_567 VPWR VGND sg13cmos5l_decap_8
Xhold391 hold391/X _3043_/Q VPWR VGND sg13cmos5l_dlygate4sd3_1
XFILLER_18_424 VPWR VGND sg13cmos5l_decap_8
XFILLER_19_958 VPWR VGND sg13cmos5l_decap_8
XFILLER_46_766 VPWR VGND sg13cmos5l_decap_4
XFILLER_34_917 VPWR VGND sg13cmos5l_decap_8
XFILLER_14_652 VPWR VGND sg13cmos5l_decap_8
XFILLER_42_994 VPWR VGND sg13cmos5l_decap_8
XFILLER_9_144 VPWR VGND sg13cmos5l_decap_8
X_2530_ _2530_/Y _1524_/Y _2529_/A _2520_/Y _2528_/Y VPWR VGND sg13cmos5l_a22oi_1
XFILLER_6_851 VPWR VGND sg13cmos5l_decap_8
XFILLER_5_350 VPWR VGND sg13cmos5l_decap_8
X_2461_ _2461_/Y _2972_/Q _2485_/A2 _2449_/Y _2635_/B VPWR VGND sg13cmos5l_a22oi_1
X_2392_ _2393_/B _2392_/A _2395_/B VPWR VGND sg13cmos5l_xnor2_1
X_3013_ _3013_/Q _3013_/CLK _3013_/D fanout158/X VPWR VGND sg13cmos5l_dfrbpq_1
XFILLER_36_243 VPWR VGND sg13cmos5l_decap_8
XFILLER_36_232 VPWR VGND sg13cmos5l_fill_2
XFILLER_36_287 VPWR VGND sg13cmos5l_fill_1
XFILLER_24_416 VPWR VGND sg13cmos5l_decap_8
XFILLER_32_482 VPWR VGND sg13cmos5l_decap_8
XFILLER_20_644 VPWR VGND sg13cmos5l_decap_8
XFILLER_22_39 VPWR VGND sg13cmos5l_decap_8
X_2728_ _2728_/Y _2741_/A _2741_/B VPWR VGND sg13cmos5l_nor2_1
X_2659_ _2659_/Y _1500_/A _2533_/A _2730_/B1 VPWR VGND sg13cmos5l_a21oi_1
Xfanout112 _2273_/A _3105_/Q VPWR VGND sg13cmos5l_buf_1
Xfanout101 _1726_/A _3125_/Q VPWR VGND sg13cmos5l_buf_1
Xfanout156 fanout156/X fanout166/X VPWR VGND sg13cmos5l_buf_1
Xfanout123 _2964_/A1 hold445/X VPWR VGND sg13cmos5l_buf_1
Xfanout145 _2244_/B _1598_/A VPWR VGND sg13cmos5l_buf_1
Xfanout134 _2332_/A _3020_/Q VPWR VGND sg13cmos5l_buf_1
Xfanout178 fanout178/X input1/X VPWR VGND sg13cmos5l_buf_1
XFILLER_47_14 VPWR VGND sg13cmos5l_decap_8
Xfanout167 fanout167/X fanout168/X VPWR VGND sg13cmos5l_buf_1
XFILLER_28_711 VPWR VGND sg13cmos5l_decap_8
XFILLER_43_736 VPWR VGND sg13cmos5l_fill_2
XFILLER_43_758 VPWR VGND sg13cmos5l_decap_8
XFILLER_24_972 VPWR VGND sg13cmos5l_decap_8
XFILLER_23_482 VPWR VGND sg13cmos5l_decap_8
XFILLER_10_143 VPWR VGND sg13cmos5l_fill_2
XFILLER_6_114 VPWR VGND sg13cmos5l_decap_8
XFILLER_10_154 VPWR VGND sg13cmos5l_decap_8
XFILLER_7_659 VPWR VGND sg13cmos5l_decap_8
XFILLER_5_0 VPWR VGND sg13cmos5l_fill_2
XFILLER_3_854 VPWR VGND sg13cmos5l_decap_8
XFILLER_38_508 VPWR VGND sg13cmos5l_fill_2
XFILLER_19_711 VPWR VGND sg13cmos5l_fill_1
XFILLER_46_541 VPWR VGND sg13cmos5l_decap_8
Xclkbuf_5_3__f_clk _3119_/CLK clkbuf_4_1_0_clk/X VPWR VGND sg13cmos5l_buf_8
XFILLER_18_276 VPWR VGND sg13cmos5l_decap_8
XFILLER_34_703 VPWR VGND sg13cmos5l_decap_8
X_1961_ _1961_/Y _2190_/C _2235_/B VPWR VGND sg13cmos5l_nor2_1
X_1892_ _1903_/A _2301_/A _1891_/Y _1883_/Y VPWR VGND sg13cmos5l_a21oi_1
XFILLER_30_953 VPWR VGND sg13cmos5l_decap_8
X_2513_ _2513_/Y _2520_/C _2963_/B _2529_/B VPWR VGND sg13cmos5l_nor3_1
XFILLER_5_180 VPWR VGND sg13cmos5l_fill_1
X_2444_ _2444_/X _3023_/Q _2672_/A VPWR VGND sg13cmos5l_or2_1
XFILLER_38_0 VPWR VGND sg13cmos5l_decap_8
X_2375_ _2376_/B _2377_/A _2377_/B VPWR VGND sg13cmos5l_xnor2_1
XFILLER_29_508 VPWR VGND sg13cmos5l_decap_8
XFILLER_17_28 VPWR VGND sg13cmos5l_decap_8
XFILLER_25_736 VPWR VGND sg13cmos5l_decap_8
XFILLER_40_706 VPWR VGND sg13cmos5l_decap_8
XFILLER_24_246 VPWR VGND sg13cmos5l_decap_8
XFILLER_21_920 VPWR VGND sg13cmos5l_decap_8
XFILLER_20_485 VPWR VGND sg13cmos5l_decap_8
XFILLER_21_997 VPWR VGND sg13cmos5l_decap_8
XFILLER_4_629 VPWR VGND sg13cmos5l_decap_8
XFILLER_0_824 VPWR VGND sg13cmos5l_decap_8
XFILLER_28_552 VPWR VGND sg13cmos5l_fill_1
XFILLER_43_533 VPWR VGND sg13cmos5l_decap_8
XFILLER_31_717 VPWR VGND sg13cmos5l_decap_8
XFILLER_24_780 VPWR VGND sg13cmos5l_decap_8
XFILLER_30_238 VPWR VGND sg13cmos5l_decap_8
XFILLER_8_935 VPWR VGND sg13cmos5l_decap_8
XFILLER_11_474 VPWR VGND sg13cmos5l_decap_4
XFILLER_12_975 VPWR VGND sg13cmos5l_decap_8
XFILLER_7_489 VPWR VGND sg13cmos5l_decap_8
XFILLER_48_1026 VPWR VGND sg13cmos5l_fill_2
XFILLER_3_651 VPWR VGND sg13cmos5l_decap_8
XFILLER_2_150 VPWR VGND sg13cmos5l_decap_8
XFILLER_2_161 VPWR VGND sg13cmos5l_fill_2
XFILLER_39_828 VPWR VGND sg13cmos5l_decap_8
X_2160_ _2160_/X _3108_/Q _2160_/B _2160_/C VPWR VGND sg13cmos5l_or3_1
X_2091_ _2282_/A _2153_/A _2322_/A VPWR VGND sg13cmos5l_nand2_1
XFILLER_0_53 VPWR VGND sg13cmos5l_decap_8
XFILLER_0_1006 VPWR VGND sg13cmos5l_decap_8
X_2993_ _2993_/Q _3010_/CLK _2993_/D fanout154/X VPWR VGND sg13cmos5l_dfrbpq_1
XFILLER_22_739 VPWR VGND sg13cmos5l_decap_8
XFILLER_34_588 VPWR VGND sg13cmos5l_decap_8
X_1944_ _2251_/B _1907_/A _1887_/Y _2308_/A VPWR VGND sg13cmos5l_o21ai_1
XFILLER_21_249 VPWR VGND sg13cmos5l_fill_1
XFILLER_9_95 VPWR VGND sg13cmos5l_decap_8
X_1875_ _2240_/C _2244_/C _1875_/B VPWR VGND sg13cmos5l_nand2_1
XFILLER_30_794 VPWR VGND sg13cmos5l_decap_4
XFILLER_0_109 VPWR VGND sg13cmos5l_decap_8
X_2427_ _3089_/D _2429_/B _2438_/A VPWR VGND sg13cmos5l_nor2_1
Xclkbuf_4_15_0_clk clkbuf_4_15_0_clk/X clkbuf_0_clk/X VPWR VGND sg13cmos5l_buf_8
X_2358_ _2358_/X _2968_/A _2358_/B _2358_/C _2358_/D VPWR VGND sg13cmos5l_and4_1
X_2289_ _2289_/X _1955_/A _2288_/Y _2282_/A VPWR VGND sg13cmos5l_a21o_1
XFILLER_28_49 VPWR VGND sg13cmos5l_decap_4
XFILLER_44_308 VPWR VGND sg13cmos5l_decap_8
XFILLER_38_894 VPWR VGND sg13cmos5l_decap_8
XFILLER_37_371 VPWR VGND sg13cmos5l_fill_1
XFILLER_44_48 VPWR VGND sg13cmos5l_decap_8
XFILLER_13_728 VPWR VGND sg13cmos5l_decap_8
XFILLER_5_916 VPWR VGND sg13cmos5l_decap_8
XFILLER_4_426 VPWR VGND sg13cmos5l_decap_8
XFILLER_0_621 VPWR VGND sg13cmos5l_decap_8
XFILLER_48_603 VPWR VGND sg13cmos5l_fill_1
XFILLER_0_698 VPWR VGND sg13cmos5l_decap_8
XFILLER_44_820 VPWR VGND sg13cmos5l_decap_8
XFILLER_16_533 VPWR VGND sg13cmos5l_decap_8
XFILLER_44_897 VPWR VGND sg13cmos5l_decap_8
XFILLER_16_577 VPWR VGND sg13cmos5l_decap_4
XFILLER_8_732 VPWR VGND sg13cmos5l_decap_8
XFILLER_7_220 VPWR VGND sg13cmos5l_decap_8
XFILLER_11_271 VPWR VGND sg13cmos5l_decap_8
X_1660_ _1662_/B _1660_/A _1745_/B VPWR VGND sg13cmos5l_nor2b_1
Xhold209 _2377_/C _3116_/Q VPWR VGND sg13cmos5l_dlygate4sd3_1
X_1591_ _1709_/B _1638_/B _1638_/C _1638_/A VPWR VGND sg13cmos5l_o21ai_1
XFILLER_4_993 VPWR VGND sg13cmos5l_decap_8
XFILLER_3_470 VPWR VGND sg13cmos5l_decap_8
X_2212_ _2221_/B _2259_/B _2212_/B VPWR VGND sg13cmos5l_and2_1
XFILLER_39_669 VPWR VGND sg13cmos5l_fill_2
X_2143_ _2144_/C _2402_/A _2210_/A _2143_/C VPWR VGND sg13cmos5l_nor3_1
Xheichips26_daftASIC_179 uio_out[1] VPWR VGND sg13cmos5l_tielo
X_2074_ _2074_/Y _2074_/A _2229_/A VPWR VGND sg13cmos5l_nand2_1
XFILLER_35_864 VPWR VGND sg13cmos5l_fill_1
XFILLER_34_352 VPWR VGND sg13cmos5l_decap_8
XFILLER_14_18 VPWR VGND sg13cmos5l_decap_8
X_2976_ _2976_/Q _3013_/CLK _2976_/D fanout160/X VPWR VGND sg13cmos5l_dfrbpq_1
X_1927_ _1927_/Y _1955_/A VPWR VGND sg13cmos5l_inv_1
X_1858_ _2143_/C _2135_/A _2138_/A VPWR VGND sg13cmos5l_nand2b_1
XFILLER_2_908 VPWR VGND sg13cmos5l_decap_8
X_1789_ _1808_/C _3077_/Q _3076_/Q _3079_/Q _3078_/Q VPWR VGND sg13cmos5l_or4_1
XFILLER_29_102 VPWR VGND sg13cmos5l_fill_2
XFILLER_45_617 VPWR VGND sg13cmos5l_decap_8
XFILLER_17_319 VPWR VGND sg13cmos5l_fill_2
XFILLER_45_639 VPWR VGND sg13cmos5l_decap_4
XFILLER_13_514 VPWR VGND sg13cmos5l_decap_8
XFILLER_41_845 VPWR VGND sg13cmos5l_decap_4
XFILLER_40_333 VPWR VGND sg13cmos5l_fill_2
XFILLER_13_569 VPWR VGND sg13cmos5l_decap_4
XFILLER_21_580 VPWR VGND sg13cmos5l_decap_8
XFILLER_5_713 VPWR VGND sg13cmos5l_decap_8
XFILLER_4_245 VPWR VGND sg13cmos5l_decap_8
XFILLER_20_50 VPWR VGND sg13cmos5l_decap_8
XFILLER_49_923 VPWR VGND sg13cmos5l_decap_8
XFILLER_1_996 VPWR VGND sg13cmos5l_decap_8
XFILLER_48_466 VPWR VGND sg13cmos5l_fill_1
XFILLER_29_691 VPWR VGND sg13cmos5l_decap_8
XFILLER_35_149 VPWR VGND sg13cmos5l_decap_4
XFILLER_16_341 VPWR VGND sg13cmos5l_decap_4
XFILLER_17_886 VPWR VGND sg13cmos5l_decap_8
X_2830_ _2833_/B _2830_/A _2830_/B VPWR VGND sg13cmos5l_and2_1
XFILLER_43_182 VPWR VGND sg13cmos5l_decap_8
XFILLER_31_355 VPWR VGND sg13cmos5l_fill_2
XFILLER_31_366 VPWR VGND sg13cmos5l_decap_8
X_2761_ _2761_/X _2761_/A _2761_/B VPWR VGND sg13cmos5l_xor2_1
XFILLER_12_580 VPWR VGND sg13cmos5l_decap_8
X_2692_ _2692_/Y _2692_/A _2692_/B VPWR VGND sg13cmos5l_xnor2_1
X_1712_ _1712_/Y _1739_/B _1644_/B _1711_/Y VPWR VGND sg13cmos5l_o21ai_1
XFILLER_8_595 VPWR VGND sg13cmos5l_decap_8
XFILLER_6_41 VPWR VGND sg13cmos5l_decap_8
X_1643_ _1648_/A _1640_/X _1641_/Y _1642_/Y VPWR VGND sg13cmos5l_o21ai_1
X_1574_ _1638_/C _1575_/A _1575_/B VPWR VGND sg13cmos5l_xnor2_1
XFILLER_4_790 VPWR VGND sg13cmos5l_decap_8
XFILLER_6_1012 VPWR VGND sg13cmos5l_decap_8
XFILLER_39_455 VPWR VGND sg13cmos5l_decap_4
XFILLER_39_499 VPWR VGND sg13cmos5l_fill_2
X_2126_ _2127_/B _2231_/B _2110_/Y _2124_/Y _2194_/B _2125_/Y VPWR VGND sg13cmos5l_a221oi_1
X_2057_ _2270_/B _2183_/B _2057_/B VPWR VGND sg13cmos5l_nand2_1
XFILLER_22_300 VPWR VGND sg13cmos5l_decap_8
XFILLER_22_355 VPWR VGND sg13cmos5l_fill_1
XFILLER_22_399 VPWR VGND sg13cmos5l_decap_8
X_2959_ _3083_/D _2959_/A VPWR VGND sg13cmos5l_inv_1
XFILLER_41_49 VPWR VGND sg13cmos5l_decap_4
XFILLER_2_705 VPWR VGND sg13cmos5l_decap_8
XFILLER_49_208 VPWR VGND sg13cmos5l_fill_1
XFILLER_46_904 VPWR VGND sg13cmos5l_decap_8
XFILLER_45_414 VPWR VGND sg13cmos5l_decap_8
XFILLER_45_458 VPWR VGND sg13cmos5l_fill_2
XFILLER_17_149 VPWR VGND sg13cmos5l_fill_1
XFILLER_13_300 VPWR VGND sg13cmos5l_decap_8
XFILLER_41_642 VPWR VGND sg13cmos5l_decap_8
XFILLER_25_171 VPWR VGND sg13cmos5l_decap_8
XFILLER_13_366 VPWR VGND sg13cmos5l_decap_8
XFILLER_15_83 VPWR VGND sg13cmos5l_decap_8
XFILLER_40_174 VPWR VGND sg13cmos5l_decap_8
XFILLER_12_1017 VPWR VGND sg13cmos5l_decap_8
XFILLER_12_1028 VPWR VGND sg13cmos5l_fill_1
XFILLER_31_60 VPWR VGND sg13cmos5l_fill_1
XFILLER_49_720 VPWR VGND sg13cmos5l_fill_2
XFILLER_1_793 VPWR VGND sg13cmos5l_decap_8
XFILLER_37_926 VPWR VGND sg13cmos5l_decap_8
XFILLER_49_797 VPWR VGND sg13cmos5l_decap_8
XFILLER_17_683 VPWR VGND sg13cmos5l_decap_8
XFILLER_23_108 VPWR VGND sg13cmos5l_fill_2
XFILLER_20_815 VPWR VGND sg13cmos5l_fill_1
X_2813_ _2818_/C _2813_/A _2813_/B VPWR VGND sg13cmos5l_and2_1
XFILLER_20_848 VPWR VGND sg13cmos5l_decap_8
XFILLER_31_174 VPWR VGND sg13cmos5l_decap_8
X_2744_ _2745_/B _2744_/A _2743_/Y VPWR VGND sg13cmos5l_nor2b_1
X_2675_ _2951_/B _2927_/A _2675_/B VPWR VGND sg13cmos5l_nand2_1
XFILLER_8_392 VPWR VGND sg13cmos5l_fill_1
X_1626_ _1626_/Y _1696_/A _1690_/B _1635_/A VPWR VGND sg13cmos5l_nand3_1
X_1557_ _1557_/X _1482_/Y _2612_/A _2596_/A VPWR VGND sg13cmos5l_a21o_1
X_1488_ _1488_/Y _1821_/A VPWR VGND sg13cmos5l_inv_1
X_3158_ _3158_/X _3158_/A VPWR VGND sg13cmos5l_buf_1
XFILLER_27_425 VPWR VGND sg13cmos5l_decap_8
XFILLER_28_937 VPWR VGND sg13cmos5l_decap_8
X_2109_ _2175_/B _2196_/B _2178_/A _2110_/C VPWR VGND sg13cmos5l_nor3_1
XFILLER_42_417 VPWR VGND sg13cmos5l_decap_8
XFILLER_36_992 VPWR VGND sg13cmos5l_decap_8
X_3089_ _3089_/Q _3136_/CLK _3089_/D fanout164/X VPWR VGND sg13cmos5l_dfrbpq_1
XFILLER_35_1006 VPWR VGND sg13cmos5l_decap_8
XFILLER_22_130 VPWR VGND sg13cmos5l_decap_8
XFILLER_22_141 VPWR VGND sg13cmos5l_fill_1
XFILLER_23_675 VPWR VGND sg13cmos5l_decap_8
XFILLER_2_502 VPWR VGND sg13cmos5l_decap_8
Xhold381 _2808_/B _2807_/Y VPWR VGND sg13cmos5l_dlygate4sd3_1
Xhold370 _2892_/A _3073_/Q VPWR VGND sg13cmos5l_dlygate4sd3_1
Xhold392 _2572_/A _3004_/Q VPWR VGND sg13cmos5l_dlygate4sd3_1
XFILLER_2_579 VPWR VGND sg13cmos5l_decap_8
XFILLER_18_403 VPWR VGND sg13cmos5l_fill_2
XFILLER_19_937 VPWR VGND sg13cmos5l_decap_8
XFILLER_45_233 VPWR VGND sg13cmos5l_decap_8
XFILLER_33_406 VPWR VGND sg13cmos5l_fill_2
XFILLER_14_631 VPWR VGND sg13cmos5l_decap_8
XFILLER_33_439 VPWR VGND sg13cmos5l_decap_8
XFILLER_42_973 VPWR VGND sg13cmos5l_decap_8
XFILLER_9_123 VPWR VGND sg13cmos5l_decap_8
XFILLER_6_830 VPWR VGND sg13cmos5l_decap_8
XFILLER_9_189 VPWR VGND sg13cmos5l_decap_8
XFILLER_10_881 VPWR VGND sg13cmos5l_decap_8
X_2460_ _2486_/B _2619_/B _2460_/B VPWR VGND sg13cmos5l_nor2_1
XFILLER_3_31 VPWR VGND sg13cmos5l_fill_1
XFILLER_3_20 VPWR VGND sg13cmos5l_decap_8
X_2391_ _3120_/D _2393_/A _2391_/B _2395_/B VPWR VGND sg13cmos5l_nor3_1
XFILLER_49_583 VPWR VGND sg13cmos5l_decap_8
X_3012_ _3012_/Q _3101_/CLK _3012_/D fanout155/X VPWR VGND sg13cmos5l_dfrbpq_1
XFILLER_37_723 VPWR VGND sg13cmos5l_decap_8
XFILLER_3_1015 VPWR VGND sg13cmos5l_decap_8
XFILLER_37_767 VPWR VGND sg13cmos5l_fill_1
XFILLER_37_756 VPWR VGND sg13cmos5l_decap_8
XFILLER_25_929 VPWR VGND sg13cmos5l_decap_8
XFILLER_36_299 VPWR VGND sg13cmos5l_decap_8
XFILLER_18_992 VPWR VGND sg13cmos5l_decap_8
XFILLER_32_450 VPWR VGND sg13cmos5l_decap_8
XFILLER_33_984 VPWR VGND sg13cmos5l_decap_8
XFILLER_22_18 VPWR VGND sg13cmos5l_decap_8
X_2727_ _2741_/B _2740_/A _2740_/C VPWR VGND sg13cmos5l_or2_1
X_2658_ _3031_/D _2653_/A _2648_/A _2646_/Y _2657_/Y VPWR VGND sg13cmos5l_a22oi_1
X_2589_ _2589_/X hold400/X _3010_/Q _2589_/S VPWR VGND sg13cmos5l_mux2_1
Xfanout113 _2148_/A _2402_/A VPWR VGND sg13cmos5l_buf_1
X_1609_ _1609_/X _3127_/Q _1609_/B _1609_/C VPWR VGND sg13cmos5l_or3_1
Xfanout102 _1816_/A hold442/X VPWR VGND sg13cmos5l_buf_1
Xfanout146 _1598_/A _3015_/Q VPWR VGND sg13cmos5l_buf_1
Xfanout135 _2331_/A _3019_/Q VPWR VGND sg13cmos5l_buf_1
Xfanout124 _2442_/B _3085_/Q VPWR VGND sg13cmos5l_buf_1
Xfanout157 fanout157/X fanout159/X VPWR VGND sg13cmos5l_buf_1
Xfanout168 fanout168/X fanout178/X VPWR VGND sg13cmos5l_buf_1
XFILLER_43_715 VPWR VGND sg13cmos5l_decap_8
XFILLER_28_778 VPWR VGND sg13cmos5l_decap_8
XFILLER_15_439 VPWR VGND sg13cmos5l_decap_8
XFILLER_27_299 VPWR VGND sg13cmos5l_decap_8
XFILLER_24_951 VPWR VGND sg13cmos5l_decap_8
XFILLER_11_612 VPWR VGND sg13cmos5l_decap_4
XFILLER_10_188 VPWR VGND sg13cmos5l_decap_8
XFILLER_12_73 VPWR VGND sg13cmos5l_decap_8
XFILLER_3_833 VPWR VGND sg13cmos5l_decap_8
XFILLER_2_310 VPWR VGND sg13cmos5l_fill_2
XFILLER_2_398 VPWR VGND sg13cmos5l_decap_8
XFILLER_2_376 VPWR VGND sg13cmos5l_decap_8
XFILLER_19_723 VPWR VGND sg13cmos5l_fill_1
XFILLER_19_767 VPWR VGND sg13cmos5l_decap_8
XFILLER_18_255 VPWR VGND sg13cmos5l_fill_1
XFILLER_21_409 VPWR VGND sg13cmos5l_decap_8
XFILLER_33_247 VPWR VGND sg13cmos5l_fill_1
XFILLER_33_269 VPWR VGND sg13cmos5l_decap_8
XFILLER_14_472 VPWR VGND sg13cmos5l_fill_2
XFILLER_15_984 VPWR VGND sg13cmos5l_decap_8
X_1960_ _2235_/B _2183_/C _2029_/C VPWR VGND sg13cmos5l_nor2_1
XFILLER_30_932 VPWR VGND sg13cmos5l_decap_8
XFILLER_41_280 VPWR VGND sg13cmos5l_decap_8
XFILLER_14_494 VPWR VGND sg13cmos5l_decap_8
X_1891_ _1891_/Y _2108_/A _1915_/B _2311_/A VPWR VGND sg13cmos5l_nand3_1
X_2512_ _2529_/B _2995_/Q _2512_/B _2512_/C _2512_/D VPWR VGND sg13cmos5l_nor4_1
X_2443_ _2443_/Y _3023_/Q _2672_/A VPWR VGND sg13cmos5l_nor2_1
X_2374_ _3114_/D _2377_/A _2393_/A VPWR VGND sg13cmos5l_nor2_1
XFILLER_25_1027 VPWR VGND sg13cmos5l_fill_2
XFILLER_37_520 VPWR VGND sg13cmos5l_decap_8
XFILLER_25_715 VPWR VGND sg13cmos5l_decap_8
XFILLER_37_597 VPWR VGND sg13cmos5l_decap_8
XFILLER_24_236 VPWR VGND sg13cmos5l_fill_1
XFILLER_33_781 VPWR VGND sg13cmos5l_decap_8
XFILLER_32_280 VPWR VGND sg13cmos5l_decap_8
XFILLER_21_976 VPWR VGND sg13cmos5l_decap_8
XFILLER_0_803 VPWR VGND sg13cmos5l_decap_8
XFILLER_47_317 VPWR VGND sg13cmos5l_fill_2
XFILLER_47_306 VPWR VGND sg13cmos5l_decap_8
XFILLER_43_512 VPWR VGND sg13cmos5l_decap_8
XFILLER_15_225 VPWR VGND sg13cmos5l_decap_8
XFILLER_28_586 VPWR VGND sg13cmos5l_decap_8
XFILLER_8_914 VPWR VGND sg13cmos5l_decap_8
XFILLER_12_954 VPWR VGND sg13cmos5l_decap_8
XFILLER_7_424 VPWR VGND sg13cmos5l_decap_8
XFILLER_7_413 VPWR VGND sg13cmos5l_decap_4
XFILLER_23_72 VPWR VGND sg13cmos5l_decap_8
XFILLER_48_1005 VPWR VGND sg13cmos5l_decap_8
XFILLER_38_317 VPWR VGND sg13cmos5l_decap_8
X_2090_ _2285_/B _2402_/A _2323_/A VPWR VGND sg13cmos5l_nor2_1
XFILLER_19_531 VPWR VGND sg13cmos5l_decap_8
XFILLER_19_542 VPWR VGND sg13cmos5l_decap_8
XFILLER_0_21 VPWR VGND sg13cmos5l_decap_8
XFILLER_47_895 VPWR VGND sg13cmos5l_decap_8
XFILLER_46_372 VPWR VGND sg13cmos5l_fill_1
XFILLER_19_586 VPWR VGND sg13cmos5l_fill_2
XFILLER_34_545 VPWR VGND sg13cmos5l_fill_1
XFILLER_34_556 VPWR VGND sg13cmos5l_fill_2
X_2992_ _2992_/Q _3010_/CLK _2992_/D fanout154/X VPWR VGND sg13cmos5l_dfrbpq_1
XFILLER_14_280 VPWR VGND sg13cmos5l_decap_8
X_1943_ _1943_/Y _1943_/A _2029_/C VPWR VGND sg13cmos5l_nor2_1
XFILLER_9_85 VPWR VGND sg13cmos5l_decap_4
XFILLER_30_773 VPWR VGND sg13cmos5l_decap_8
X_1874_ _1915_/B _2244_/C _1875_/B VPWR VGND sg13cmos5l_and2_1
XFILLER_9_1010 VPWR VGND sg13cmos5l_decap_8
X_2426_ _2433_/A _2641_/B _2641_/C _2426_/C VPWR VGND sg13cmos5l_nor3_1
X_2357_ _3158_/A _2966_/A _2355_/X _2350_/Y VPWR VGND sg13cmos5l_a21oi_1
XFILLER_28_28 VPWR VGND sg13cmos5l_decap_8
X_2288_ _2288_/Y _1872_/Y _1875_/B _2205_/Y VPWR VGND sg13cmos5l_a21oi_1
XFILLER_38_873 VPWR VGND sg13cmos5l_decap_8
XFILLER_38_862 VPWR VGND sg13cmos5l_fill_2
XFILLER_38_851 VPWR VGND sg13cmos5l_decap_8
XFILLER_25_578 VPWR VGND sg13cmos5l_decap_8
XFILLER_40_548 VPWR VGND sg13cmos5l_decap_4
XFILLER_20_272 VPWR VGND sg13cmos5l_decap_8
XFILLER_20_283 VPWR VGND sg13cmos5l_fill_1
XFILLER_4_449 VPWR VGND sg13cmos5l_fill_1
XFILLER_0_600 VPWR VGND sg13cmos5l_decap_8
XFILLER_0_677 VPWR VGND sg13cmos5l_decap_8
XFILLER_47_114 VPWR VGND sg13cmos5l_decap_8
XFILLER_28_383 VPWR VGND sg13cmos5l_fill_1
XFILLER_29_895 VPWR VGND sg13cmos5l_decap_8
XFILLER_44_876 VPWR VGND sg13cmos5l_decap_8
XFILLER_28_394 VPWR VGND sg13cmos5l_fill_2
XFILLER_43_375 VPWR VGND sg13cmos5l_fill_1
XFILLER_31_515 VPWR VGND sg13cmos5l_decap_8
XFILLER_12_740 VPWR VGND sg13cmos5l_fill_1
XFILLER_8_711 VPWR VGND sg13cmos5l_decap_8
XFILLER_11_250 VPWR VGND sg13cmos5l_decap_8
XFILLER_15_1026 VPWR VGND sg13cmos5l_fill_2
XFILLER_12_784 VPWR VGND sg13cmos5l_decap_8
XFILLER_8_788 VPWR VGND sg13cmos5l_decap_8
X_1590_ _1732_/C _1632_/A _1646_/D VPWR VGND sg13cmos5l_nor2_1
XFILLER_4_972 VPWR VGND sg13cmos5l_decap_8
XFILLER_3_460 VPWR VGND sg13cmos5l_decap_4
X_2211_ _2213_/C _2227_/B _2025_/Y _2003_/B VPWR VGND sg13cmos5l_a21oi_1
XFILLER_22_4 VPWR VGND sg13cmos5l_decap_8
X_2142_ _2142_/Y _2194_/B _2142_/B VPWR VGND sg13cmos5l_nand2_1
X_2073_ _2083_/A _2068_/Y _2072_/Y _2047_/C VPWR VGND sg13cmos5l_o21ai_1
XFILLER_19_383 VPWR VGND sg13cmos5l_decap_8
XFILLER_35_843 VPWR VGND sg13cmos5l_decap_8
XFILLER_34_342 VPWR VGND sg13cmos5l_decap_4
XFILLER_35_887 VPWR VGND sg13cmos5l_decap_8
XFILLER_22_537 VPWR VGND sg13cmos5l_fill_1
X_2975_ _2975_/Q _3122_/CLK _2975_/D fanout153/X VPWR VGND sg13cmos5l_dfrbpq_1
X_1926_ _1955_/A _1901_/Y _2139_/B _1896_/Y VPWR VGND sg13cmos5l_a21o_1
XFILLER_30_592 VPWR VGND sg13cmos5l_fill_1
X_1857_ _2227_/A _2147_/A _2135_/A VPWR VGND sg13cmos5l_nor2_1
XFILLER_30_18 VPWR VGND sg13cmos5l_decap_8
XFILLER_30_29 VPWR VGND sg13cmos5l_fill_1
X_1788_ _2944_/B _1805_/B _1796_/B VPWR VGND sg13cmos5l_nor2b_1
XFILLER_1_419 VPWR VGND sg13cmos5l_fill_1
XFILLER_39_27 VPWR VGND sg13cmos5l_decap_8
XFILLER_39_49 VPWR VGND sg13cmos5l_decap_4
X_2409_ _2409_/Y _2412_/C _2410_/C _2412_/A VPWR VGND sg13cmos5l_a21oi_1
XFILLER_44_139 VPWR VGND sg13cmos5l_decap_4
XFILLER_37_180 VPWR VGND sg13cmos5l_fill_1
XFILLER_25_342 VPWR VGND sg13cmos5l_fill_2
XFILLER_26_887 VPWR VGND sg13cmos5l_fill_2
XFILLER_13_537 VPWR VGND sg13cmos5l_fill_1
XFILLER_13_548 VPWR VGND sg13cmos5l_decap_8
XFILLER_41_879 VPWR VGND sg13cmos5l_fill_2
XFILLER_5_769 VPWR VGND sg13cmos5l_decap_8
XFILLER_49_902 VPWR VGND sg13cmos5l_decap_8
XFILLER_1_975 VPWR VGND sg13cmos5l_decap_8
XFILLER_0_474 VPWR VGND sg13cmos5l_decap_8
XFILLER_0_496 VPWR VGND sg13cmos5l_decap_8
XFILLER_49_979 VPWR VGND sg13cmos5l_decap_8
XFILLER_36_618 VPWR VGND sg13cmos5l_decap_8
XFILLER_16_320 VPWR VGND sg13cmos5l_decap_8
XFILLER_44_684 VPWR VGND sg13cmos5l_decap_8
XFILLER_43_161 VPWR VGND sg13cmos5l_decap_8
XFILLER_32_813 VPWR VGND sg13cmos5l_decap_4
XFILLER_31_323 VPWR VGND sg13cmos5l_fill_2
Xclkbuf_4_14_0_clk clkbuf_4_14_0_clk/X clkbuf_0_clk/X VPWR VGND sg13cmos5l_buf_8
X_2760_ _2761_/B _2740_/Y _2757_/Y _2759_/Y VPWR VGND sg13cmos5l_a21oi_1
XFILLER_8_530 VPWR VGND sg13cmos5l_fill_2
X_2691_ _2692_/B _2679_/A _2681_/B _2678_/Y VPWR VGND sg13cmos5l_o21ai_1
XFILLER_8_563 VPWR VGND sg13cmos5l_decap_8
X_1711_ _1711_/Y _1693_/A _1693_/B _1740_/A VPWR VGND sg13cmos5l_a21oi_1
XFILLER_6_20 VPWR VGND sg13cmos5l_decap_8
X_1642_ _1642_/Y _1696_/A _2362_/A VPWR VGND sg13cmos5l_nor2_1
X_1573_ _1573_/Y _1572_/B _1771_/A VPWR VGND sg13cmos5l_nand2b_1
XFILLER_3_290 VPWR VGND sg13cmos5l_fill_2
XFILLER_39_434 VPWR VGND sg13cmos5l_decap_8
XFILLER_39_478 VPWR VGND sg13cmos5l_decap_8
XFILLER_27_607 VPWR VGND sg13cmos5l_fill_2
X_2125_ _2125_/Y _2317_/A _2241_/A VPWR VGND sg13cmos5l_nand2_1
X_2056_ _2290_/B _2227_/A _2056_/B VPWR VGND sg13cmos5l_nor2_1
XFILLER_41_109 VPWR VGND sg13cmos5l_fill_2
XFILLER_23_813 VPWR VGND sg13cmos5l_decap_4
XFILLER_34_172 VPWR VGND sg13cmos5l_decap_8
XFILLER_23_879 VPWR VGND sg13cmos5l_decap_4
XFILLER_41_28 VPWR VGND sg13cmos5l_decap_8
X_2958_ _2959_/A hold332/X _3103_/D _2960_/A VPWR VGND sg13cmos5l_o21ai_1
X_1909_ _2054_/A _2266_/A _2138_/A _2029_/B VPWR VGND sg13cmos5l_nand3_1
X_2889_ _2889_/Y _2889_/A _2889_/B VPWR VGND sg13cmos5l_xnor2_1
XFILLER_1_249 VPWR VGND sg13cmos5l_fill_2
XFILLER_18_629 VPWR VGND sg13cmos5l_decap_8
XFILLER_17_139 VPWR VGND sg13cmos5l_fill_1
XFILLER_25_150 VPWR VGND sg13cmos5l_decap_8
XFILLER_26_673 VPWR VGND sg13cmos5l_decap_8
XFILLER_40_142 VPWR VGND sg13cmos5l_decap_8
XFILLER_15_73 VPWR VGND sg13cmos5l_decap_8
XFILLER_9_349 VPWR VGND sg13cmos5l_decap_8
XFILLER_31_83 VPWR VGND sg13cmos5l_fill_1
Xoutput4 uo_out[0] _3155_/X VPWR VGND sg13cmos5l_buf_1
XFILLER_1_772 VPWR VGND sg13cmos5l_decap_8
XFILLER_49_776 VPWR VGND sg13cmos5l_decap_8
XFILLER_48_242 VPWR VGND sg13cmos5l_fill_1
XFILLER_36_404 VPWR VGND sg13cmos5l_decap_8
XFILLER_45_982 VPWR VGND sg13cmos5l_decap_8
XFILLER_17_662 VPWR VGND sg13cmos5l_decap_8
XFILLER_44_470 VPWR VGND sg13cmos5l_decap_8
XFILLER_16_194 VPWR VGND sg13cmos5l_decap_8
XFILLER_32_665 VPWR VGND sg13cmos5l_fill_2
XFILLER_32_676 VPWR VGND sg13cmos5l_decap_8
X_2812_ _2812_/Y _2813_/A _2813_/B VPWR VGND sg13cmos5l_nor2_1
XFILLER_13_890 VPWR VGND sg13cmos5l_decap_8
X_2743_ _2743_/Y _2757_/A _2759_/A _2743_/C VPWR VGND sg13cmos5l_nand3_1
XFILLER_8_371 VPWR VGND sg13cmos5l_fill_2
X_2674_ _2922_/C _2674_/A _2947_/B VPWR VGND sg13cmos5l_nor2_1
X_1625_ _1635_/A _1604_/A _1660_/A _1632_/A VPWR VGND sg13cmos5l_o21ai_1
X_1556_ _1556_/Y _1560_/A _1560_/B _1555_/Y VPWR VGND sg13cmos5l_o21ai_1
XFILLER_28_1014 VPWR VGND sg13cmos5l_decap_8
X_1487_ _1823_/A _1487_/A VPWR VGND sg13cmos5l_inv_1
XFILLER_39_253 VPWR VGND sg13cmos5l_decap_8
XFILLER_28_916 VPWR VGND sg13cmos5l_decap_8
X_3157_ _3157_/X _3157_/A VPWR VGND sg13cmos5l_buf_1
XFILLER_27_404 VPWR VGND sg13cmos5l_decap_8
X_2108_ _2110_/C _2108_/A _2108_/B VPWR VGND sg13cmos5l_nor2_1
XFILLER_36_971 VPWR VGND sg13cmos5l_decap_8
X_3088_ _3088_/Q _3091_/CLK _3088_/D fanout160/X VPWR VGND sg13cmos5l_dfrbpq_1
X_2039_ _2039_/Y _2074_/A _2039_/B VPWR VGND sg13cmos5l_nand2_1
XFILLER_23_643 VPWR VGND sg13cmos5l_decap_8
XFILLER_10_359 VPWR VGND sg13cmos5l_decap_8
Xhold371 _2634_/S _3028_/Q VPWR VGND sg13cmos5l_dlygate4sd3_1
XFILLER_2_525 VPWR VGND sg13cmos5l_decap_8
Xhold360 _3069_/D _2878_/Y VPWR VGND sg13cmos5l_dlygate4sd3_1
Xhold382 _2815_/A _3050_/Q VPWR VGND sg13cmos5l_dlygate4sd3_1
Xhold393 _2995_/D _2573_/Y VPWR VGND sg13cmos5l_dlygate4sd3_1
XFILLER_19_916 VPWR VGND sg13cmos5l_decap_8
XFILLER_46_724 VPWR VGND sg13cmos5l_decap_8
XFILLER_18_459 VPWR VGND sg13cmos5l_decap_8
XFILLER_26_83 VPWR VGND sg13cmos5l_decap_8
XFILLER_42_952 VPWR VGND sg13cmos5l_decap_8
XFILLER_9_102 VPWR VGND sg13cmos5l_decap_8
XFILLER_13_175 VPWR VGND sg13cmos5l_fill_2
XFILLER_14_676 VPWR VGND sg13cmos5l_decap_8
XFILLER_14_687 VPWR VGND sg13cmos5l_fill_2
XFILLER_41_495 VPWR VGND sg13cmos5l_decap_4
XFILLER_13_197 VPWR VGND sg13cmos5l_decap_8
XFILLER_42_93 VPWR VGND sg13cmos5l_decap_8
XFILLER_6_886 VPWR VGND sg13cmos5l_decap_8
XFILLER_5_385 VPWR VGND sg13cmos5l_decap_8
X_2390_ _2395_/B _2390_/A _2390_/B VPWR VGND sg13cmos5l_and2_1
X_3011_ _3011_/Q _3101_/CLK _3011_/D fanout155/X VPWR VGND sg13cmos5l_dfrbpq_1
XFILLER_37_702 VPWR VGND sg13cmos5l_decap_8
XFILLER_25_908 VPWR VGND sg13cmos5l_decap_8
XFILLER_36_278 VPWR VGND sg13cmos5l_decap_8
XFILLER_18_971 VPWR VGND sg13cmos5l_decap_8
XFILLER_17_481 VPWR VGND sg13cmos5l_decap_8
XFILLER_33_963 VPWR VGND sg13cmos5l_decap_8
XFILLER_20_679 VPWR VGND sg13cmos5l_decap_4
X_2726_ _2740_/C _2726_/A _2726_/B _2726_/C VPWR VGND sg13cmos5l_nor3_1
X_2657_ _2657_/Y _2746_/A _2657_/B VPWR VGND sg13cmos5l_nand2_1
X_1608_ _1609_/C _1696_/B _1696_/C _1608_/C _1738_/A VPWR VGND sg13cmos5l_nor4_1
X_2588_ _3008_/D hold402/X hold400/X _2589_/S VPWR VGND sg13cmos5l_mux2_1
Xclkbuf_5_28__f_clk _3057_/CLK clkbuf_4_14_0_clk/X VPWR VGND sg13cmos5l_buf_8
Xfanout103 _2353_/S _3122_/Q VPWR VGND sg13cmos5l_buf_1
Xfanout136 _2605_/A _2131_/B VPWR VGND sg13cmos5l_buf_1
Xfanout147 _1862_/B _1852_/B VPWR VGND sg13cmos5l_buf_1
Xfanout114 _2402_/A _2297_/A VPWR VGND sg13cmos5l_buf_1
X_1539_ _1540_/B _3134_/Q _1539_/B VPWR VGND sg13cmos5l_nand2_1
Xfanout125 _1800_/A _3085_/Q VPWR VGND sg13cmos5l_buf_1
Xfanout169 fanout169/X fanout171/X VPWR VGND sg13cmos5l_buf_1
Xfanout158 fanout158/X fanout159/X VPWR VGND sg13cmos5l_buf_1
XFILLER_41_1022 VPWR VGND sg13cmos5l_decap_8
XFILLER_28_702 VPWR VGND sg13cmos5l_decap_4
XFILLER_15_418 VPWR VGND sg13cmos5l_decap_8
XFILLER_24_930 VPWR VGND sg13cmos5l_decap_8
XFILLER_27_278 VPWR VGND sg13cmos5l_decap_4
XFILLER_10_112 VPWR VGND sg13cmos5l_decap_8
XFILLER_11_635 VPWR VGND sg13cmos5l_decap_4
XFILLER_11_657 VPWR VGND sg13cmos5l_decap_4
XFILLER_7_639 VPWR VGND sg13cmos5l_decap_8
XFILLER_6_149 VPWR VGND sg13cmos5l_decap_8
XFILLER_3_812 VPWR VGND sg13cmos5l_decap_8
XFILLER_5_2 VPWR VGND sg13cmos5l_fill_1
XFILLER_3_889 VPWR VGND sg13cmos5l_decap_8
XFILLER_2_344 VPWR VGND sg13cmos5l_decap_4
XFILLER_18_201 VPWR VGND sg13cmos5l_decap_4
XFILLER_37_93 VPWR VGND sg13cmos5l_decap_8
XFILLER_19_779 VPWR VGND sg13cmos5l_decap_4
XFILLER_33_215 VPWR VGND sg13cmos5l_fill_1
XFILLER_34_749 VPWR VGND sg13cmos5l_decap_8
XFILLER_15_963 VPWR VGND sg13cmos5l_decap_8
XFILLER_18_1013 VPWR VGND sg13cmos5l_decap_8
XFILLER_42_760 VPWR VGND sg13cmos5l_fill_1
XFILLER_30_911 VPWR VGND sg13cmos5l_decap_8
X_1890_ _1890_/Y _1915_/B _2311_/A VPWR VGND sg13cmos5l_nand2_1
XFILLER_30_988 VPWR VGND sg13cmos5l_decap_8
X_2511_ _2963_/B _2511_/A _2996_/Q _2515_/C _2512_/C VPWR VGND sg13cmos5l_nor4_1
XFILLER_6_683 VPWR VGND sg13cmos5l_decap_8
XFILLER_5_171 VPWR VGND sg13cmos5l_decap_8
X_2442_ _2672_/A _2442_/A _2442_/B _2442_/C VPWR VGND sg13cmos5l_nor3_1
X_2373_ _2398_/A _2373_/A _2373_/B _2373_/C VPWR VGND sg13cmos5l_nand3_1
XFILLER_25_1006 VPWR VGND sg13cmos5l_decap_8
XFILLER_49_392 VPWR VGND sg13cmos5l_decap_8
XFILLER_37_576 VPWR VGND sg13cmos5l_decap_8
XFILLER_33_29 VPWR VGND sg13cmos5l_decap_8
XFILLER_33_771 VPWR VGND sg13cmos5l_fill_1
XFILLER_21_955 VPWR VGND sg13cmos5l_decap_8
X_2709_ _2726_/B _2709_/A _2710_/A _2709_/C VPWR VGND sg13cmos5l_nor3_1
XFILLER_0_859 VPWR VGND sg13cmos5l_decap_8
XFILLER_28_510 VPWR VGND sg13cmos5l_decap_8
XFILLER_28_532 VPWR VGND sg13cmos5l_decap_8
XFILLER_43_502 VPWR VGND sg13cmos5l_decap_4
XFILLER_28_565 VPWR VGND sg13cmos5l_decap_8
XFILLER_15_204 VPWR VGND sg13cmos5l_fill_2
XFILLER_16_727 VPWR VGND sg13cmos5l_decap_8
XFILLER_15_248 VPWR VGND sg13cmos5l_decap_8
XFILLER_30_218 VPWR VGND sg13cmos5l_fill_1
XFILLER_12_933 VPWR VGND sg13cmos5l_decap_8
XFILLER_23_281 VPWR VGND sg13cmos5l_fill_2
XFILLER_23_51 VPWR VGND sg13cmos5l_decap_4
XFILLER_48_1028 VPWR VGND sg13cmos5l_fill_1
XFILLER_3_686 VPWR VGND sg13cmos5l_decap_8
Xclkbuf_5_11__f_clk _3010_/CLK clkbuf_4_5_0_clk/X VPWR VGND sg13cmos5l_buf_8
XFILLER_48_70 VPWR VGND sg13cmos5l_decap_8
XFILLER_38_307 VPWR VGND sg13cmos5l_fill_1
XFILLER_17_7 VPWR VGND sg13cmos5l_decap_8
XFILLER_19_510 VPWR VGND sg13cmos5l_decap_4
XFILLER_47_874 VPWR VGND sg13cmos5l_decap_8
XFILLER_46_351 VPWR VGND sg13cmos5l_decap_8
XFILLER_46_362 VPWR VGND sg13cmos5l_fill_2
XFILLER_34_524 VPWR VGND sg13cmos5l_decap_8
XFILLER_0_88 VPWR VGND sg13cmos5l_decap_8
X_2991_ _2991_/Q clkload2/A _2991_/D fanout154/X VPWR VGND sg13cmos5l_dfrbpq_1
X_1942_ _1945_/B _1941_/Y _2076_/A VPWR VGND sg13cmos5l_nand2b_1
X_1873_ _1875_/B _2022_/A _1908_/C VPWR VGND sg13cmos5l_nand2_1
XFILLER_9_64 VPWR VGND sg13cmos5l_decap_8
XFILLER_43_0 VPWR VGND sg13cmos5l_decap_8
X_2425_ _2641_/D _2432_/A _3093_/Q VPWR VGND sg13cmos5l_nand2_1
X_2356_ _3159_/A _3087_/Q _2355_/X _2350_/Y VPWR VGND sg13cmos5l_a21oi_1
X_2287_ _2287_/Y _2287_/A _3105_/D VPWR VGND sg13cmos5l_nor2b_1
XFILLER_29_329 VPWR VGND sg13cmos5l_decap_8
XFILLER_37_351 VPWR VGND sg13cmos5l_decap_8
XFILLER_25_535 VPWR VGND sg13cmos5l_decap_8
XFILLER_40_527 VPWR VGND sg13cmos5l_decap_8
XFILLER_20_251 VPWR VGND sg13cmos5l_decap_8
XFILLER_21_774 VPWR VGND sg13cmos5l_decap_8
XFILLER_21_785 VPWR VGND sg13cmos5l_fill_2
XFILLER_4_417 VPWR VGND sg13cmos5l_decap_4
XFILLER_0_656 VPWR VGND sg13cmos5l_decap_8
XFILLER_48_649 VPWR VGND sg13cmos5l_decap_8
XFILLER_47_159 VPWR VGND sg13cmos5l_fill_2
XFILLER_18_62 VPWR VGND sg13cmos5l_decap_8
XFILLER_29_874 VPWR VGND sg13cmos5l_decap_8
XFILLER_18_84 VPWR VGND sg13cmos5l_decap_8
XFILLER_44_855 VPWR VGND sg13cmos5l_decap_8
XFILLER_34_61 VPWR VGND sg13cmos5l_fill_2
XFILLER_11_240 VPWR VGND sg13cmos5l_fill_1
XFILLER_12_752 VPWR VGND sg13cmos5l_fill_1
XFILLER_15_1005 VPWR VGND sg13cmos5l_decap_8
XFILLER_8_767 VPWR VGND sg13cmos5l_decap_8
XFILLER_7_255 VPWR VGND sg13cmos5l_decap_8
XFILLER_4_951 VPWR VGND sg13cmos5l_decap_8
X_2210_ _2210_/Y _2210_/A _2210_/B VPWR VGND sg13cmos5l_nand2_1
XFILLER_39_605 VPWR VGND sg13cmos5l_decap_8
XFILLER_39_649 VPWR VGND sg13cmos5l_decap_8
X_2141_ _2142_/B _2227_/A _2139_/Y _2140_/Y VPWR VGND sg13cmos5l_o21ai_1
XFILLER_15_4 VPWR VGND sg13cmos5l_fill_2
XFILLER_22_1009 VPWR VGND sg13cmos5l_decap_8
X_2072_ _2072_/Y _2076_/B _2072_/B VPWR VGND sg13cmos5l_nor2_1
XFILLER_47_693 VPWR VGND sg13cmos5l_fill_2
XFILLER_22_527 VPWR VGND sg13cmos5l_fill_2
X_2974_ _2974_/Q _3091_/CLK _2974_/D fanout160/X VPWR VGND sg13cmos5l_dfrbpq_1
X_1925_ _2139_/B _2147_/A _2011_/D VPWR VGND sg13cmos5l_nand2_1
X_1856_ _1856_/Y _1972_/C _1845_/B _1853_/Y _2183_/B VPWR VGND sg13cmos5l_a22oi_1
X_1787_ _1796_/B _2442_/B _2669_/B VPWR VGND sg13cmos5l_nand2b_1
XFILLER_1_409 VPWR VGND sg13cmos5l_fill_1
X_2408_ _3108_/D _2412_/C _2414_/B VPWR VGND sg13cmos5l_xnor2_1
X_2339_ _2358_/C _2339_/A _2339_/B VPWR VGND sg13cmos5l_nor2_1
XFILLER_29_148 VPWR VGND sg13cmos5l_decap_8
XFILLER_44_118 VPWR VGND sg13cmos5l_decap_8
XFILLER_26_833 VPWR VGND sg13cmos5l_decap_8
XFILLER_38_693 VPWR VGND sg13cmos5l_decap_8
XFILLER_25_321 VPWR VGND sg13cmos5l_decap_8
XFILLER_26_855 VPWR VGND sg13cmos5l_decap_8
XFILLER_41_803 VPWR VGND sg13cmos5l_decap_8
XFILLER_38_1027 VPWR VGND sg13cmos5l_fill_2
XFILLER_38_1016 VPWR VGND sg13cmos5l_decap_8
XFILLER_25_365 VPWR VGND sg13cmos5l_fill_2
XFILLER_41_858 VPWR VGND sg13cmos5l_decap_8
XFILLER_25_387 VPWR VGND sg13cmos5l_decap_4
XFILLER_9_509 VPWR VGND sg13cmos5l_decap_8
XFILLER_5_748 VPWR VGND sg13cmos5l_decap_8
XFILLER_4_236 VPWR VGND sg13cmos5l_decap_4
XFILLER_20_85 VPWR VGND sg13cmos5l_decap_8
XFILLER_1_954 VPWR VGND sg13cmos5l_decap_8
XFILLER_0_453 VPWR VGND sg13cmos5l_decap_8
XFILLER_49_958 VPWR VGND sg13cmos5l_decap_8
XFILLER_48_479 VPWR VGND sg13cmos5l_fill_2
XFILLER_17_822 VPWR VGND sg13cmos5l_decap_8
XFILLER_17_833 VPWR VGND sg13cmos5l_fill_2
XFILLER_17_855 VPWR VGND sg13cmos5l_decap_8
XFILLER_45_71 VPWR VGND sg13cmos5l_fill_2
XFILLER_16_387 VPWR VGND sg13cmos5l_decap_8
XFILLER_32_847 VPWR VGND sg13cmos5l_decap_4
X_2690_ _2690_/Y _2692_/A VPWR VGND sg13cmos5l_inv_1
XFILLER_8_542 VPWR VGND sg13cmos5l_decap_8
X_1710_ _1710_/Y _1710_/A _1710_/B _1710_/C _1710_/D VPWR VGND sg13cmos5l_nor4_1
X_1641_ _1641_/Y _1740_/A _1693_/A _1709_/B _1641_/D VPWR VGND sg13cmos5l_nor4_1
XFILLER_6_76 VPWR VGND sg13cmos5l_decap_8
Xclkbuf_5_9__f_clk clkload2/A clkbuf_4_4_0_clk/X VPWR VGND sg13cmos5l_buf_8
X_1572_ _1726_/C _1584_/A _1572_/B VPWR VGND sg13cmos5l_nor2_1
XFILLER_39_424 VPWR VGND sg13cmos5l_decap_8
X_2124_ _2124_/Y _2135_/B _2294_/C _2048_/Y VPWR VGND sg13cmos5l_o21ai_1
XFILLER_48_991 VPWR VGND sg13cmos5l_decap_8
XFILLER_26_118 VPWR VGND sg13cmos5l_decap_8
XFILLER_47_490 VPWR VGND sg13cmos5l_decap_8
X_2055_ _2089_/C _2055_/A _2055_/B _2241_/A VPWR VGND sg13cmos5l_nand3_1
XFILLER_34_151 VPWR VGND sg13cmos5l_decap_8
XFILLER_23_825 VPWR VGND sg13cmos5l_decap_8
XFILLER_23_858 VPWR VGND sg13cmos5l_decap_8
XFILLER_22_335 VPWR VGND sg13cmos5l_decap_8
X_2957_ _3082_/D _2963_/C _2957_/B VPWR VGND sg13cmos5l_nand2_1
XFILLER_10_519 VPWR VGND sg13cmos5l_decap_8
XFILLER_22_379 VPWR VGND sg13cmos5l_fill_1
X_1908_ _2021_/B _2118_/A _2147_/A _1908_/C _2151_/B VPWR VGND sg13cmos5l_or4_1
X_2888_ _2895_/C _2889_/A _2889_/B VPWR VGND sg13cmos5l_and2_1
X_1839_ _1839_/X _2131_/A _1830_/Y _1837_/X VPWR VGND sg13cmos5l_a21o_1
XFILLER_1_217 VPWR VGND sg13cmos5l_fill_1
XFILLER_18_608 VPWR VGND sg13cmos5l_decap_8
XFILLER_46_939 VPWR VGND sg13cmos5l_decap_8
XFILLER_45_449 VPWR VGND sg13cmos5l_decap_4
XFILLER_14_814 VPWR VGND sg13cmos5l_decap_8
XFILLER_26_652 VPWR VGND sg13cmos5l_decap_8
XFILLER_14_858 VPWR VGND sg13cmos5l_decap_8
XFILLER_41_677 VPWR VGND sg13cmos5l_decap_8
XFILLER_15_52 VPWR VGND sg13cmos5l_decap_8
XFILLER_9_328 VPWR VGND sg13cmos5l_decap_8
XFILLER_9_339 VPWR VGND sg13cmos5l_fill_1
XFILLER_21_390 VPWR VGND sg13cmos5l_fill_1
Xoutput5 uo_out[1] _3156_/X VPWR VGND sg13cmos5l_buf_1
XFILLER_1_751 VPWR VGND sg13cmos5l_decap_8
XFILLER_49_755 VPWR VGND sg13cmos5l_decap_8
XFILLER_0_283 VPWR VGND sg13cmos5l_decap_8
XFILLER_17_641 VPWR VGND sg13cmos5l_decap_4
XFILLER_45_961 VPWR VGND sg13cmos5l_decap_8
XFILLER_20_806 VPWR VGND sg13cmos5l_decap_8
XFILLER_32_644 VPWR VGND sg13cmos5l_decap_8
X_2811_ _2811_/Y _2822_/A _2811_/B _2813_/B VPWR VGND sg13cmos5l_nor3_1
XFILLER_20_828 VPWR VGND sg13cmos5l_decap_8
XFILLER_31_154 VPWR VGND sg13cmos5l_decap_4
X_2742_ _2744_/A _2759_/A _2743_/C _2757_/A VPWR VGND sg13cmos5l_a21oi_1
XFILLER_9_884 VPWR VGND sg13cmos5l_decap_8
X_2673_ _2928_/B _2673_/A _2947_/B VPWR VGND sg13cmos5l_nor2_1
X_1624_ _1628_/D _1816_/A _1690_/B VPWR VGND sg13cmos5l_nand2_1
X_1555_ _1555_/Y _1751_/A _2331_/A _1755_/A _2332_/A VPWR VGND sg13cmos5l_a22oi_1
X_1486_ _2112_/A _2596_/C VPWR VGND sg13cmos5l_inv_1
XFILLER_39_232 VPWR VGND sg13cmos5l_decap_8
X_3156_ _3156_/X _3156_/A VPWR VGND sg13cmos5l_buf_1
XFILLER_39_298 VPWR VGND sg13cmos5l_decap_8
X_2107_ _2116_/B _2323_/C _2106_/Y _1923_/Y VPWR VGND sg13cmos5l_o21ai_1
X_3087_ _3087_/Q _3091_/CLK _3087_/D fanout160/X VPWR VGND sg13cmos5l_dfrbpq_1
XFILLER_42_408 VPWR VGND sg13cmos5l_fill_2
XFILLER_36_950 VPWR VGND sg13cmos5l_decap_8
X_2038_ _2039_/B _2272_/C _2038_/B _2163_/A VPWR VGND sg13cmos5l_nand3_1
XFILLER_35_471 VPWR VGND sg13cmos5l_decap_8
XFILLER_23_622 VPWR VGND sg13cmos5l_decap_8
XFILLER_11_806 VPWR VGND sg13cmos5l_decap_8
XFILLER_10_316 VPWR VGND sg13cmos5l_decap_4
XFILLER_22_187 VPWR VGND sg13cmos5l_decap_8
Xhold361 _2552_/A _2993_/Q VPWR VGND sg13cmos5l_dlygate4sd3_1
Xhold350 _3062_/D _2850_/Y VPWR VGND sg13cmos5l_dlygate4sd3_1
Xhold383 _2816_/B _2815_/Y VPWR VGND sg13cmos5l_dlygate4sd3_1
Xhold394 _1487_/A _3129_/Q VPWR VGND sg13cmos5l_dlygate4sd3_1
Xhold372 _2627_/A _2635_/B VPWR VGND sg13cmos5l_dlygate4sd3_1
Xclkbuf_4_13_0_clk clkbuf_4_13_0_clk/X clkbuf_0_clk/X VPWR VGND sg13cmos5l_buf_8
XFILLER_18_438 VPWR VGND sg13cmos5l_decap_8
XFILLER_33_419 VPWR VGND sg13cmos5l_decap_8
XFILLER_42_931 VPWR VGND sg13cmos5l_decap_8
XFILLER_27_983 VPWR VGND sg13cmos5l_decap_8
XFILLER_13_143 VPWR VGND sg13cmos5l_fill_1
XFILLER_13_154 VPWR VGND sg13cmos5l_decap_8
XFILLER_9_158 VPWR VGND sg13cmos5l_decap_8
XFILLER_42_72 VPWR VGND sg13cmos5l_decap_8
XFILLER_5_331 VPWR VGND sg13cmos5l_decap_8
XFILLER_6_865 VPWR VGND sg13cmos5l_decap_8
XFILLER_5_364 VPWR VGND sg13cmos5l_decap_8
XFILLER_47_7 VPWR VGND sg13cmos5l_decap_8
XFILLER_3_44 VPWR VGND sg13cmos5l_decap_8
XFILLER_49_552 VPWR VGND sg13cmos5l_decap_8
X_3010_ _3010_/Q _3010_/CLK _3010_/D fanout155/X VPWR VGND sg13cmos5l_dfrbpq_1
XFILLER_36_213 VPWR VGND sg13cmos5l_decap_4
XFILLER_36_257 VPWR VGND sg13cmos5l_decap_8
XFILLER_18_950 VPWR VGND sg13cmos5l_decap_8
XFILLER_33_942 VPWR VGND sg13cmos5l_decap_8
XFILLER_20_658 VPWR VGND sg13cmos5l_decap_8
X_2725_ _2741_/A _3038_/Q _2749_/B VPWR VGND sg13cmos5l_xnor2_1
X_2656_ _2657_/B _2656_/A _2656_/B VPWR VGND sg13cmos5l_xnor2_1
X_1607_ _1738_/A _1696_/A _1705_/C VPWR VGND sg13cmos5l_nand2_1
X_2587_ _3007_/D _2577_/A hold402/X _2589_/S VPWR VGND sg13cmos5l_mux2_1
Xfanout104 _2392_/A hold447/X VPWR VGND sg13cmos5l_buf_1
Xfanout126 _2442_/C _2919_/A VPWR VGND sg13cmos5l_buf_1
Xfanout137 _2131_/B _3018_/Q VPWR VGND sg13cmos5l_buf_1
Xfanout115 _2294_/A _2297_/A VPWR VGND sg13cmos5l_buf_1
X_1538_ _1538_/Y _3134_/Q _1539_/B VPWR VGND sg13cmos5l_nor2_1
Xfanout159 fanout159/X fanout166/X VPWR VGND sg13cmos5l_buf_1
XFILLER_47_28 VPWR VGND sg13cmos5l_decap_4
XFILLER_41_1001 VPWR VGND sg13cmos5l_decap_8
Xfanout148 _1852_/B hold448/X VPWR VGND sg13cmos5l_buf_1
XFILLER_28_725 VPWR VGND sg13cmos5l_decap_8
XFILLER_28_758 VPWR VGND sg13cmos5l_decap_4
XFILLER_16_909 VPWR VGND sg13cmos5l_decap_8
XFILLER_27_246 VPWR VGND sg13cmos5l_fill_2
XFILLER_27_257 VPWR VGND sg13cmos5l_decap_8
XFILLER_35_290 VPWR VGND sg13cmos5l_decap_8
XFILLER_24_986 VPWR VGND sg13cmos5l_decap_8
XFILLER_23_496 VPWR VGND sg13cmos5l_decap_4
XFILLER_7_618 VPWR VGND sg13cmos5l_decap_8
XFILLER_10_168 VPWR VGND sg13cmos5l_fill_1
XFILLER_6_128 VPWR VGND sg13cmos5l_decap_8
XFILLER_2_323 VPWR VGND sg13cmos5l_decap_8
XFILLER_3_868 VPWR VGND sg13cmos5l_decap_8
XFILLER_18_224 VPWR VGND sg13cmos5l_decap_4
XFILLER_19_736 VPWR VGND sg13cmos5l_decap_8
XFILLER_46_566 VPWR VGND sg13cmos5l_decap_8
XFILLER_46_555 VPWR VGND sg13cmos5l_fill_1
XFILLER_37_72 VPWR VGND sg13cmos5l_decap_8
XFILLER_34_717 VPWR VGND sg13cmos5l_fill_1
XFILLER_34_728 VPWR VGND sg13cmos5l_decap_8
XFILLER_15_942 VPWR VGND sg13cmos5l_decap_8
XFILLER_14_474 VPWR VGND sg13cmos5l_fill_1
XFILLER_30_967 VPWR VGND sg13cmos5l_decap_8
X_2510_ _2520_/C _2995_/Q _2996_/Q _2510_/C _2512_/D VPWR VGND sg13cmos5l_nor4_1
XFILLER_6_662 VPWR VGND sg13cmos5l_decap_8
X_2441_ _2619_/B hold332/X _3103_/Q VPWR VGND sg13cmos5l_nand2b_1
X_2372_ _2373_/C _2440_/B _2372_/B VPWR VGND sg13cmos5l_nor2_1
XFILLER_37_500 VPWR VGND sg13cmos5l_fill_1
XFILLER_20_433 VPWR VGND sg13cmos5l_decap_4
XFILLER_21_934 VPWR VGND sg13cmos5l_decap_8
XFILLER_20_466 VPWR VGND sg13cmos5l_fill_2
XFILLER_20_499 VPWR VGND sg13cmos5l_decap_8
X_2708_ _2710_/B _2709_/A _2709_/C VPWR VGND sg13cmos5l_or2_1
XFILLER_3_109 VPWR VGND sg13cmos5l_decap_8
X_2639_ _2656_/A _2649_/A _2639_/B VPWR VGND sg13cmos5l_nand2_1
XFILLER_0_838 VPWR VGND sg13cmos5l_decap_8
XFILLER_48_809 VPWR VGND sg13cmos5l_decap_8
XFILLER_16_706 VPWR VGND sg13cmos5l_fill_2
XFILLER_43_547 VPWR VGND sg13cmos5l_decap_8
XFILLER_12_912 VPWR VGND sg13cmos5l_decap_8
XFILLER_23_260 VPWR VGND sg13cmos5l_decap_8
XFILLER_24_794 VPWR VGND sg13cmos5l_decap_8
XFILLER_11_466 VPWR VGND sg13cmos5l_fill_2
XFILLER_12_989 VPWR VGND sg13cmos5l_decap_8
XFILLER_8_949 VPWR VGND sg13cmos5l_decap_8
XFILLER_11_488 VPWR VGND sg13cmos5l_decap_8
XFILLER_3_665 VPWR VGND sg13cmos5l_decap_8
XFILLER_47_853 VPWR VGND sg13cmos5l_decap_8
XFILLER_46_330 VPWR VGND sg13cmos5l_decap_8
XFILLER_0_67 VPWR VGND sg13cmos5l_decap_8
XFILLER_19_588 VPWR VGND sg13cmos5l_fill_1
XFILLER_34_558 VPWR VGND sg13cmos5l_fill_1
X_2990_ _2990_/Q _3101_/CLK _2990_/D fanout154/X VPWR VGND sg13cmos5l_dfrbpq_1
XFILLER_9_32 VPWR VGND sg13cmos5l_fill_2
X_1941_ _1941_/Y _2186_/C _2029_/B _2240_/A VPWR VGND sg13cmos5l_o21ai_1
XFILLER_15_783 VPWR VGND sg13cmos5l_decap_8
X_1872_ _1872_/Y _2267_/A _2078_/B VPWR VGND sg13cmos5l_nor2_1
XFILLER_30_753 VPWR VGND sg13cmos5l_decap_8
XFILLER_31_1011 VPWR VGND sg13cmos5l_decap_8
XFILLER_7_993 VPWR VGND sg13cmos5l_decap_8
X_2424_ _2641_/C _2429_/C _2439_/A VPWR VGND sg13cmos5l_or2_1
X_2355_ _2355_/X _3088_/Q _2358_/B _2358_/C _2358_/D VPWR VGND sg13cmos5l_and4_1
X_2286_ _2287_/A _2286_/A _2286_/B _2286_/C VPWR VGND sg13cmos5l_nor3_1
XFILLER_25_514 VPWR VGND sg13cmos5l_decap_8
XFILLER_33_591 VPWR VGND sg13cmos5l_decap_4
XFILLER_20_230 VPWR VGND sg13cmos5l_decap_8
XFILLER_0_635 VPWR VGND sg13cmos5l_decap_8
XFILLER_48_617 VPWR VGND sg13cmos5l_decap_4
XFILLER_29_853 VPWR VGND sg13cmos5l_decap_8
XFILLER_44_834 VPWR VGND sg13cmos5l_decap_8
XFILLER_16_547 VPWR VGND sg13cmos5l_decap_8
XFILLER_28_396 VPWR VGND sg13cmos5l_fill_1
XFILLER_43_366 VPWR VGND sg13cmos5l_decap_4
XFILLER_12_731 VPWR VGND sg13cmos5l_decap_8
XFILLER_24_591 VPWR VGND sg13cmos5l_decap_8
XFILLER_12_764 VPWR VGND sg13cmos5l_decap_8
XFILLER_15_1028 VPWR VGND sg13cmos5l_fill_1
XFILLER_34_84 VPWR VGND sg13cmos5l_fill_2
XFILLER_8_746 VPWR VGND sg13cmos5l_decap_8
XFILLER_12_797 VPWR VGND sg13cmos5l_decap_8
XFILLER_7_234 VPWR VGND sg13cmos5l_decap_8
XFILLER_11_285 VPWR VGND sg13cmos5l_decap_8
XFILLER_7_289 VPWR VGND sg13cmos5l_fill_1
XFILLER_7_278 VPWR VGND sg13cmos5l_decap_8
XFILLER_4_930 VPWR VGND sg13cmos5l_decap_8
XFILLER_3_484 VPWR VGND sg13cmos5l_decap_8
X_2140_ _2140_/Y _2153_/A _2169_/B VPWR VGND sg13cmos5l_nor2_1
X_2071_ _2072_/B _2183_/B _2308_/B _2118_/B VPWR VGND sg13cmos5l_nand3_1
XFILLER_19_341 VPWR VGND sg13cmos5l_decap_8
XFILLER_22_506 VPWR VGND sg13cmos5l_decap_8
XFILLER_34_366 VPWR VGND sg13cmos5l_decap_8
X_2973_ _2973_/Q _3122_/CLK _2973_/D fanout152/X VPWR VGND sg13cmos5l_dfrbpq_1
X_1924_ _2005_/A _2153_/A _2323_/A VPWR VGND sg13cmos5l_nand2_1
XFILLER_30_583 VPWR VGND sg13cmos5l_decap_8
X_1855_ _2308_/C _2246_/C _1888_/B VPWR VGND sg13cmos5l_nand2_1
X_1786_ _1810_/B _3069_/Q _1786_/B VPWR VGND sg13cmos5l_nand2_1
XFILLER_7_790 VPWR VGND sg13cmos5l_decap_8
X_2407_ _3107_/D _2410_/C _2407_/B VPWR VGND sg13cmos5l_nor2_1
X_2338_ _2350_/A _2338_/A _2338_/B _2338_/C _2338_/D VPWR VGND sg13cmos5l_nor4_1
X_2269_ _2269_/Y _2272_/C _2269_/B _2269_/C VPWR VGND sg13cmos5l_nor3_1
XFILLER_38_672 VPWR VGND sg13cmos5l_decap_8
XFILLER_26_812 VPWR VGND sg13cmos5l_decap_8
XFILLER_25_344 VPWR VGND sg13cmos5l_fill_1
XFILLER_13_528 VPWR VGND sg13cmos5l_decap_8
XFILLER_21_594 VPWR VGND sg13cmos5l_decap_8
XFILLER_5_727 VPWR VGND sg13cmos5l_decap_8
XFILLER_4_215 VPWR VGND sg13cmos5l_decap_8
XFILLER_4_259 VPWR VGND sg13cmos5l_fill_1
XFILLER_20_64 VPWR VGND sg13cmos5l_decap_8
XFILLER_1_933 VPWR VGND sg13cmos5l_decap_8
XFILLER_0_432 VPWR VGND sg13cmos5l_decap_8
XFILLER_49_937 VPWR VGND sg13cmos5l_decap_8
XFILLER_29_95 VPWR VGND sg13cmos5l_decap_8
XFILLER_35_119 VPWR VGND sg13cmos5l_decap_8
XFILLER_28_182 VPWR VGND sg13cmos5l_decap_8
XFILLER_45_83 VPWR VGND sg13cmos5l_decap_8
XFILLER_44_653 VPWR VGND sg13cmos5l_decap_8
XFILLER_31_325 VPWR VGND sg13cmos5l_fill_1
XFILLER_32_826 VPWR VGND sg13cmos5l_decap_8
XFILLER_8_510 VPWR VGND sg13cmos5l_decap_8
XFILLER_8_532 VPWR VGND sg13cmos5l_fill_1
X_1640_ _1640_/X _1646_/B _1640_/B _1708_/B VPWR VGND sg13cmos5l_and3_1
XFILLER_6_55 VPWR VGND sg13cmos5l_decap_8
X_1571_ _1572_/B _1571_/A _1571_/B VPWR VGND sg13cmos5l_xor2_1
XFILLER_3_292 VPWR VGND sg13cmos5l_fill_1
XFILLER_39_403 VPWR VGND sg13cmos5l_decap_8
XFILLER_6_1026 VPWR VGND sg13cmos5l_fill_2
X_2123_ _2123_/X _2194_/B _2121_/Y _1983_/Y VPWR VGND sg13cmos5l_a21o_1
XFILLER_48_970 VPWR VGND sg13cmos5l_decap_8
XFILLER_19_182 VPWR VGND sg13cmos5l_decap_8
X_2054_ _2241_/A _2054_/A _2054_/B VPWR VGND sg13cmos5l_nand2_1
XFILLER_35_686 VPWR VGND sg13cmos5l_fill_2
XFILLER_22_314 VPWR VGND sg13cmos5l_fill_2
X_2956_ _2957_/B _2956_/A _2960_/A VPWR VGND sg13cmos5l_nand2_1
XFILLER_22_369 VPWR VGND sg13cmos5l_fill_2
X_1907_ _1917_/B _1907_/A _2151_/B VPWR VGND sg13cmos5l_or2_1
X_2887_ _2887_/Y _2889_/A _2902_/B VPWR VGND sg13cmos5l_nand2_1
XFILLER_31_892 VPWR VGND sg13cmos5l_decap_8
X_1838_ _1838_/Y _2131_/A _1830_/Y _1837_/X VPWR VGND sg13cmos5l_a21oi_1
XFILLER_2_719 VPWR VGND sg13cmos5l_decap_8
X_1769_ _1769_/Y _2392_/A _3123_/Q _2353_/S VPWR VGND sg13cmos5l_nor3_1
XFILLER_46_918 VPWR VGND sg13cmos5l_decap_8
XFILLER_17_108 VPWR VGND sg13cmos5l_fill_1
XFILLER_45_428 VPWR VGND sg13cmos5l_decap_8
XFILLER_38_491 VPWR VGND sg13cmos5l_decap_8
XFILLER_13_314 VPWR VGND sg13cmos5l_decap_8
XFILLER_25_185 VPWR VGND sg13cmos5l_decap_8
XFILLER_41_656 VPWR VGND sg13cmos5l_decap_8
XFILLER_9_307 VPWR VGND sg13cmos5l_decap_8
XFILLER_13_336 VPWR VGND sg13cmos5l_decap_8
XFILLER_15_97 VPWR VGND sg13cmos5l_decap_8
XFILLER_40_188 VPWR VGND sg13cmos5l_decap_8
XFILLER_22_892 VPWR VGND sg13cmos5l_fill_1
XFILLER_5_524 VPWR VGND sg13cmos5l_decap_8
XFILLER_5_579 VPWR VGND sg13cmos5l_decap_8
XFILLER_5_557 VPWR VGND sg13cmos5l_decap_8
Xoutput6 uo_out[2] _3157_/X VPWR VGND sg13cmos5l_buf_1
XFILLER_31_96 VPWR VGND sg13cmos5l_fill_2
XFILLER_1_730 VPWR VGND sg13cmos5l_decap_8
XFILLER_49_734 VPWR VGND sg13cmos5l_decap_8
XFILLER_0_262 VPWR VGND sg13cmos5l_decap_8
XFILLER_48_277 VPWR VGND sg13cmos5l_decap_4
XFILLER_45_940 VPWR VGND sg13cmos5l_decap_8
XFILLER_36_428 VPWR VGND sg13cmos5l_fill_2
XFILLER_17_620 VPWR VGND sg13cmos5l_fill_2
XFILLER_16_152 VPWR VGND sg13cmos5l_fill_2
XFILLER_17_697 VPWR VGND sg13cmos5l_decap_8
XFILLER_32_623 VPWR VGND sg13cmos5l_decap_8
X_2810_ _2813_/B _2810_/A _2810_/B _2810_/C _2851_/B VPWR VGND sg13cmos5l_nor4_1
X_2741_ _2743_/C _2741_/A _2741_/B _2741_/C VPWR VGND sg13cmos5l_or3_1
XFILLER_9_863 VPWR VGND sg13cmos5l_decap_8
XFILLER_31_188 VPWR VGND sg13cmos5l_decap_8
XFILLER_8_340 VPWR VGND sg13cmos5l_decap_8
XFILLER_8_384 VPWR VGND sg13cmos5l_fill_1
X_2672_ _2672_/Y _2672_/A _3080_/Q VPWR VGND sg13cmos5l_nor2b_1
X_1623_ _1690_/B _1646_/B _1646_/C _1726_/C VPWR VGND sg13cmos5l_a21oi_1
X_1554_ _1560_/B _3135_/Q _2331_/A VPWR VGND sg13cmos5l_xor2_1
X_1485_ _1755_/A _3136_/Q VPWR VGND sg13cmos5l_inv_1
.ends
